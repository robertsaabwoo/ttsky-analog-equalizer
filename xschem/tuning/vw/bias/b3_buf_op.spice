* B3a: diff_amp_inv stage currents at vtail = 0.85 V, tt/27C, inputs balanced at the ring's CM
.lib /home/ttuser/pdk/sky130A/libs.tech/ngspice/sky130.lib.spice tt
.include /home/ttuser/ssh_analog/ttsky-analog-equalizer/xschem/tuning/cml/.netlists/frozen.inc
Vdd vdd 0 1.8
Vt vtail 0 0.85
Vip vip 0 1.4
Vim vim 0 1.4
xb vdd 0 om op vim vip vtail diff_amp_inv
.control
  op
  let i1 = @m.xb.xm3.msky130_fd_pr__nfet_01v8[id]
  let i2 = @m.xb.xm4.msky130_fd_pr__nfet_01v8[id]
  print i1 i2 v(xb.net1) v(xb.net2) v(om) v(op) v(xb.vo-_temp)
  foreach cm 1.2 1.3 1.5
    alter Vip dc=$cm
    alter Vim dc=$cm
    op
    echo "cm=$cm"
    print @m.xb.xm3.msky130_fd_pr__nfet_01v8[id] @m.xb.xm4.msky130_fd_pr__nfet_01v8[id]
  end
.endc
.end
