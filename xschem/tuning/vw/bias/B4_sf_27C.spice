* B4 (sf 27C): clock buffer -- o = diff_amp_inv @ vtail 0.85 V, n = cml_clkbuf @ cml_bias
* corner: mos=sf rc=typ temp=27C
.param mc_mm_switch=0
.param mc_pr_switch=0
.include "/home/ttuser/pdk/sky130A/libs.tech/ngspice/corners/sf.spice"
.include "/home/ttuser/pdk/sky130A/libs.tech/ngspice/r+c/res_typical__cap_typical.spice"
.include "/home/ttuser/pdk/sky130A/libs.tech/ngspice/r+c/res_typical__cap_typical__lin.spice"
.include "/home/ttuser/pdk/sky130A/libs.tech/ngspice/corners/sf/specialized_cells.spice"
.temp 27

.include /home/ttuser/pdk/sky130A/libs.ref/sky130_fd_sc_hd/spice/sky130_fd_sc_hd.spice
.include /home/ttuser/ssh_analog/ttsky-analog-equalizer/xschem/tuning/cml/.netlists/frozen.inc
.include /home/ttuser/ssh_analog/ttsky-analog-equalizer/xschem/tuning/cml/.netlists/cml_cells.inc
.include /home/ttuser/ssh_analog/ttsky-analog-equalizer/xschem/tuning/vw/cx_cells.inc
.include /home/ttuser/ssh_analog/ttsky-analog-equalizer/xschem/tuning/vw/bias/cml_bias.inc
.include /home/ttuser/ssh_analog/ttsky-analog-equalizer/xschem/tuning/vw/bias/cml_clkbuf.inc
.subckt ring_core Vdd Vss vctrl t7 t8
x1 Vdd Vss t7 n1 t8 n2 vctrl ring_inverter
x2 Vdd Vss n1 n4 n2 n3 vctrl ring_inverter
x3 Vdd Vss n4 n5 n3 n6 vctrl ring_inverter
x5 Vdd Vss n5 n9 n6 n10 vctrl ring_inverter
x4 Vdd Vss n9 t7 n10 t8 vctrl ring_inverter
.ends

.options method=gear reltol=0.001
Vdd vdd 0 1.8
Vb vbias 0 0.9
Vt vtail 0 0.85
Vc vctrl 0 0.79
xref vdd 0 vbn cml_bias
Vd vd 0 PWL(0.00000e+00 -0.0750 1.66500e-09 -0.0750 1.76500e-09 -0.0750 3.33000e-09 -0.0750 3.43000e-09 -0.0750 4.99500e-09 -0.0750 5.09500e-09 -0.0750 6.66000e-09 -0.0750 6.76000e-09 -0.0750 8.32500e-09 -0.0750 8.42500e-09 -0.0750 9.99000e-09 -0.0750 1.00900e-08 0.0750 1.16550e-08 0.0750 1.17550e-08 -0.0750 1.33200e-08 -0.0750 1.34200e-08 -0.0750 1.49850e-08 -0.0750 1.50850e-08 -0.0750 1.66500e-08 -0.0750 1.67500e-08 -0.0750 1.83150e-08 -0.0750 1.84150e-08 -0.0750 1.99800e-08 -0.0750 2.00800e-08 0.0750 2.16450e-08 0.0750 2.17450e-08 0.0750 2.33100e-08 0.0750 2.34100e-08 -0.0750 2.49750e-08 -0.0750 2.50750e-08 -0.0750 2.66400e-08 -0.0750 2.67400e-08 -0.0750 2.83050e-08 -0.0750 2.84050e-08 -0.0750 2.99700e-08 -0.0750 3.00700e-08 0.0750 3.16350e-08 0.0750 3.17350e-08 -0.0750 3.33000e-08 -0.0750 3.34000e-08 0.0750 3.49650e-08 0.0750 3.50650e-08 -0.0750 3.66300e-08 -0.0750 3.67300e-08 -0.0750 3.82950e-08 -0.0750 3.83950e-08 -0.0750 3.99600e-08 -0.0750 4.00600e-08 0.0750 4.16250e-08 0.0750 4.17250e-08 0.0750 4.32900e-08 0.0750 4.33900e-08 0.0750 4.49550e-08 0.0750 4.50550e-08 0.0750 4.66200e-08 0.0750 4.67200e-08 -0.0750 4.82850e-08 -0.0750 4.83850e-08 -0.0750 4.99500e-08 -0.0750 5.00500e-08 0.0750 5.16150e-08 0.0750 5.17150e-08 -0.0750 5.32800e-08 -0.0750 5.33800e-08 -0.0750 5.49450e-08 -0.0750 5.50450e-08 -0.0750 5.66100e-08 -0.0750 5.67100e-08 0.0750 5.82750e-08 0.0750 5.83750e-08 -0.0750 5.99400e-08 -0.0750 6.00400e-08 0.0750 6.16050e-08 0.0750 6.17050e-08 0.0750 6.32700e-08 0.0750 6.33700e-08 -0.0750 6.49350e-08 -0.0750 6.50350e-08 -0.0750 6.66000e-08 -0.0750 6.67000e-08 0.0750 6.82650e-08 0.0750 6.83650e-08 0.0750 6.99300e-08 0.0750 7.00300e-08 0.0750 7.15950e-08 0.0750 7.16950e-08 -0.0750 7.32600e-08 -0.0750 7.33600e-08 0.0750 7.49250e-08 0.0750 7.50250e-08 -0.0750 7.65900e-08 -0.0750 7.66900e-08 0.0750 7.82550e-08 0.0750 7.83550e-08 -0.0750 7.99200e-08 -0.0750 8.00200e-08 -0.0750 8.15850e-08 -0.0750 8.16850e-08 0.0750 8.32500e-08 0.0750 8.33500e-08 0.0750 8.49150e-08 0.0750 8.50150e-08 0.0750 8.65800e-08 0.0750 8.66800e-08 0.0750 8.82450e-08 0.0750 8.83450e-08 0.0750 8.99100e-08 0.0750 9.00100e-08 -0.0750 9.15750e-08 -0.0750 9.16750e-08 0.0750 9.32400e-08 0.0750 9.33400e-08 -0.0750 9.49050e-08 -0.0750 9.50050e-08 -0.0750 9.65700e-08 -0.0750 9.66700e-08 -0.0750 9.82350e-08 -0.0750 9.83350e-08 -0.0750 9.99000e-08 -0.0750 1.00000e-07 0.0750 1.01565e-07 0.0750 1.01665e-07 0.0750 1.03230e-07 0.0750 1.03330e-07 0.0750 1.04895e-07 0.0750 1.04995e-07 -0.0750 1.06560e-07 -0.0750 1.06660e-07 -0.0750 1.08225e-07 -0.0750 1.08325e-07 -0.0750 1.09890e-07 -0.0750 1.09990e-07 0.0750 1.11555e-07 0.0750 1.11655e-07 -0.0750 1.13220e-07 -0.0750 1.13320e-07 -0.0750 1.14885e-07 -0.0750 1.14985e-07 0.0750)
Ep dp 0 vol='1.3 + v(vd)'
Em dm 0 vol='1.3 - v(vd)'
xor vdd_oring 0 vctrl ot7 ot8 ring_core
Iok ot7 0 PULSE(0 50u 1n 50p 50p 200p 1e3)
xob vdd_obuf 0 ock ockb ot7 ot8 vtail diff_amp_inv
xopd vdd_opd 0 odn oup ock ockb dp dm vbias cml_pd_cx3w
xoc1 orp ock ockb vdd 0 vbias cml2cmos
xoc2 orm ockb ock vdd 0 vbias cml2cmos
Voring vdd_oring 0 1.8
Vobuf vdd_obuf 0 1.8
Vopd vdd_opd 0 1.8
xnr vdd_nring 0 vctrl nt7 nt8 ring_core
Ink nt7 0 PULSE(0 50u 1n 50p 50p 200p 1e3)
xnb vdd_nbuf 0 nck nckb nt7 nt8 vbn cml_clkbuf
xnpd vdd_npd 0 ndn nup nck nckb dp dm vbn cml_pd_cx3w
xnc1 nrp nck nckb vdd 0 vbn cml2cmos
xnc2 nrm nckb nck vdd 0 vbn cml2cmos
Vnring vdd_nring 0 1.8
Vnbuf vdd_nbuf 0 1.8
Vnpd vdd_npd 0 1.8
.control
  set width=200
  save v(ot7) v(ot8) v(nt7) v(nt8) v(ock) v(ockb) v(nck) v(nckb) v(orp) v(nrp) i(Vobuf) i(Vnbuf) i(Vopd) i(Vnpd)
  tran 5p 1.1655e-07
  meas tran ota when v(ot7)=v(ot8) rise=1 td=6.000e-08
  meas tran otb when v(ot7)=v(ot8) rise=21 td=6.000e-08
  let of_mhz = 20/(otb-ota)/1e6
  print of_mhz
  let ockd = v(ock)-v(ockb)
  meas tran ock_pp pp ockd from=6.000e-08 to=1.1655e-07
  meas tran ock_min min v(ock) from=6.000e-08 to=1.1655e-07
  meas tran ock_max max v(ock) from=6.000e-08 to=1.1655e-07
  meas tran orp_pp pp v(orp) from=6.000e-08 to=1.1655e-07
  meas tran oi_buf avg i(Vobuf) from=6.000e-08 to=1.1655e-07
  meas tran oi_pd avg i(Vopd) from=6.000e-08 to=1.1655e-07
  meas tran nta when v(nt7)=v(nt8) rise=1 td=6.000e-08
  meas tran ntb when v(nt7)=v(nt8) rise=21 td=6.000e-08
  let nf_mhz = 20/(ntb-nta)/1e6
  print nf_mhz
  let nckd = v(nck)-v(nckb)
  meas tran nck_pp pp nckd from=6.000e-08 to=1.1655e-07
  meas tran nck_min min v(nck) from=6.000e-08 to=1.1655e-07
  meas tran nck_max max v(nck) from=6.000e-08 to=1.1655e-07
  meas tran nrp_pp pp v(nrp) from=6.000e-08 to=1.1655e-07
  meas tran ni_buf avg i(Vnbuf) from=6.000e-08 to=1.1655e-07
  meas tran ni_pd avg i(Vnpd) from=6.000e-08 to=1.1655e-07
.endc
.end
