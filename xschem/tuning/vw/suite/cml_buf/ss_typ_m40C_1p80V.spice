* SUITE cml_buf ss_typ_m40C_1p80V: cold start, 3000 ns
* GENERATED by gen_cml.py -- do not edit.
* S3_buf (cx3w PD + cml_bias + cml_clkbuf + scaled filter, vtail=0.85): the CML CDR, closed loop, same stimulus and
* window as power/P0_chain (PRBS7, 200 mVpp, 500 ohm / 5 pF pad, cload 50f).
* Every leaf cell has its own supply source.
* Leaf devices instantiated: 209
* SRC vx1 x1:CTLE
* SRC vx2_x6 x2:CDR_cml_cx/x6:tiny_pll_charge_pump
* SRC vx2_x8 x2:CDR_cml_cx/x8:tiny_pll_bias_gen
* SRC vx2_x2 x2:CDR_cml_cx/x2:tiny_pll_loop_filter
* SRC vx2_x1_x1 x2:CDR_cml_cx/x1:ring_core/x1:ring_inverter
* SRC vx2_x1_x2 x2:CDR_cml_cx/x1:ring_core/x2:ring_inverter
* SRC vx2_x1_x3 x2:CDR_cml_cx/x1:ring_core/x3:ring_inverter
* SRC vx2_x1_x5 x2:CDR_cml_cx/x1:ring_core/x5:ring_inverter
* SRC vx2_x1_x4 x2:CDR_cml_cx/x1:ring_core/x4:ring_inverter
* SRC vx2_x9 x2:CDR_cml_cx/x9:cml_clkbuf
* SRC vx2_xref x2:CDR_cml_cx/xref:cml_bias
* SRC vx2_x3_x5_xm x2:CDR_cml_cx/x3:cml_pd_cx3w/x5:cml_dff/xm:cml_latch
* SRC vx2_x3_x5_xs x2:CDR_cml_cx/x3:cml_pd_cx3w/x5:cml_dff/xs:cml_latch
* SRC vx2_x3_x1_xm x2:CDR_cml_cx/x3:cml_pd_cx3w/x1:cml_dff/xm:cml_latch
* SRC vx2_x3_x1_xs x2:CDR_cml_cx/x3:cml_pd_cx3w/x1:cml_dff/xs:cml_latch
* SRC vx2_x3_x2_xm x2:CDR_cml_cx/x3:cml_pd_cx3w/x2:cml_dff/xm:cml_latch
* SRC vx2_x3_x2_xs x2:CDR_cml_cx/x3:cml_pd_cx3w/x2:cml_dff/xs:cml_latch
* SRC vx2_x3_x3_xm x2:CDR_cml_cx/x3:cml_pd_cx3w/x3:cml_dff/xm:cml_latch
* SRC vx2_x3_x3_xs x2:CDR_cml_cx/x3:cml_pd_cx3w/x3:cml_dff/xs:cml_latch
* SRC vx2_x3_xc5 x2:CDR_cml_cx/x3:cml_pd_cx3w/xc5:cml2cmos_w2
* SRC vx2_x3_xc2 x2:CDR_cml_cx/x3:cml_pd_cx3w/xc2:cml2cmos_w2
* SRC vx2_x3_xcb x2:CDR_cml_cx/x3:cml_pd_cx3w/xcb:cml2cmos_w2
* SRC vx2_x3_x6 x2:CDR_cml_cx/x3:cml_pd_cx3w/x6:cx_xor
* SRC vx2_x3_x7 x2:CDR_cml_cx/x3:cml_pd_cx3w/x7:cx_xor
* SRC vx2_x11 x2:CDR_cml_cx/x11:cml2cmos
* SRC vx2_x12 x2:CDR_cml_cx/x12:cml2cmos
* SRC vx2_x20 x2:CDR_cml_cx/x20:vctrl_precharge
* SRC vx3 x3:inverter_chain
* SRC vx4 x4:inverter_chain
* corner: mos=ss rc=typ temp=-40C
.param mc_mm_switch=0
.param mc_pr_switch=0
.include "/home/ttuser/pdk/sky130A/libs.tech/ngspice/corners/ss.spice"
.include "/home/ttuser/pdk/sky130A/libs.tech/ngspice/r+c/res_typical__cap_typical.spice"
.include "/home/ttuser/pdk/sky130A/libs.tech/ngspice/r+c/res_typical__cap_typical__lin.spice"
.include "/home/ttuser/pdk/sky130A/libs.tech/ngspice/corners/ss/specialized_cells.spice"
.temp -40

.include /home/ttuser/pdk/sky130A/libs.ref/sky130_fd_sc_hd/spice/sky130_fd_sc_hd.spice
.include /home/ttuser/ssh_analog/ttsky-analog-equalizer/xschem/tuning/vw/frozen_scaled.inc
.include /home/ttuser/ssh_analog/ttsky-analog-equalizer/xschem/tuning/cml/.netlists/cml_cells.inc
.include /home/ttuser/ssh_analog/ttsky-analog-equalizer/xschem/tuning/vw/cx_cells.inc
.include /home/ttuser/ssh_analog/ttsky-analog-equalizer/xschem/tuning/vw/bias/cml_bias.inc
.include /home/ttuser/ssh_analog/ttsky-analog-equalizer/xschem/tuning/vw/bias/cml_clkbuf.inc
.include /home/ttuser/ssh_analog/ttsky-analog-equalizer/xschem/tuning/vw/bias/cp_bias.inc
.include /home/ttuser/ssh_analog/ttsky-analog-equalizer/xschem/tuning/vw/S3_buf_top.inc
.include /home/ttuser/ssh_analog/ttsky-analog-equalizer/xschem/tuning/e2e_prbs6u.inc
.options method=gear reltol=0.001 abstol=1e-12
.param vcm=0.9 amp=0.2 rpad=500 cpad=5p
Vx1 vdd_x1 0 1.8
Vx2_x6 vdd_x2_x6 0 1.8
Vx2_x8 vdd_x2_x8 0 1.8
Vx2_x2 vdd_x2_x2 0 1.8
Vx2_x1_x1 vdd_x2_x1_x1 0 1.8
Vx2_x1_x2 vdd_x2_x1_x2 0 1.8
Vx2_x1_x3 vdd_x2_x1_x3 0 1.8
Vx2_x1_x5 vdd_x2_x1_x5 0 1.8
Vx2_x1_x4 vdd_x2_x1_x4 0 1.8
Vx2_x9 vdd_x2_x9 0 1.8
Vx2_xref vdd_x2_xref 0 1.8
Vx2_x3_x5_xm vdd_x2_x3_x5_xm 0 1.8
Vx2_x3_x5_xs vdd_x2_x3_x5_xs 0 1.8
Vx2_x3_x1_xm vdd_x2_x3_x1_xm 0 1.8
Vx2_x3_x1_xs vdd_x2_x3_x1_xs 0 1.8
Vx2_x3_x2_xm vdd_x2_x3_x2_xm 0 1.8
Vx2_x3_x2_xs vdd_x2_x3_x2_xs 0 1.8
Vx2_x3_x3_xm vdd_x2_x3_x3_xm 0 1.8
Vx2_x3_x3_xs vdd_x2_x3_x3_xs 0 1.8
Vx2_x3_xc5 vdd_x2_x3_xc5 0 1.8
Vx2_x3_xc2 vdd_x2_x3_xc2 0 1.8
Vx2_x3_xcb vdd_x2_x3_xcb 0 1.8
Vx2_x3_x6 vdd_x2_x3_x6 0 1.8
Vx2_x3_x7 vdd_x2_x3_x7 0 1.8
Vx2_x11 vdd_x2_x11 0 1.8
Vx2_x12 vdd_x2_x12 0 1.8
Vx2_x20 vdd_x2_x20 0 1.8
Vx3 vdd_x3 0 1.8
Vx4 vdd_x4 0 1.8
Vtie vtie 0 1.8
Vtail vtail 0 0.85
Vb  vbias 0 0.9
Edinp dinp 0 vol='vcm + 0.5*amp*(v(dsrc)-0.5)'
Edinm dinm 0 vol='vcm - 0.5*amp*(v(dsrc)-0.5)'
Rpadp dinp cinp 'rpad'
Cpadp cinp 0    'cpad'
Rpadm dinm cinm 'rpad'
Cpadm cinm 0    'cpad'
Clp clkout_p 0 50f
Cln clkout_n 0 50f
x1 eq_p eq_m cinp cinm vdd_x1 0 vbias CTLE
x2_x6 vdd_x2_x6 vdd_x2_x6 0 0 x2_net1 x2_net2 x2_net3 x2_bias_n x2_bias_p tiny_pll_charge_pump
x2_x8 0 0 vdd_x2_x8 vdd_x2_x8 x2_bias_n vtie 0 x2_bias_p tiny_pll_bias_gen
x2_x2 0 0 vdd_x2_x2 vdd_x2_x2 x2_net1 tiny_pll_loop_filter
x2_x1_x1 vdd_x2_x1_x1 0 x2_t7 x2_x1_n1 x2_t8 x2_x1_n2 x2_net1 ring_inverter
x2_x1_x2 vdd_x2_x1_x2 0 x2_x1_n1 x2_x1_n4 x2_x1_n2 x2_x1_n3 x2_net1 ring_inverter
x2_x1_x3 vdd_x2_x1_x3 0 x2_x1_n4 x2_x1_n5 x2_x1_n3 x2_x1_n6 x2_net1 ring_inverter
x2_x1_x5 vdd_x2_x1_x5 0 x2_x1_n5 x2_x1_n9 x2_x1_n6 x2_x1_n10 x2_net1 ring_inverter
x2_x1_x4 vdd_x2_x1_x4 0 x2_x1_n9 x2_t7 x2_x1_n10 x2_t8 x2_net1 ring_inverter
x2_x9 vdd_x2_x9 0 x2_ck x2_ckb x2_t7 x2_t8 x2_vbn cml_clkbuf
x2_xref vdd_x2_xref 0 x2_vbn cml_bias
x2_x3_x5_xm x2_x3_x5_m x2_x3_x5_mb eq_p eq_m vdd_x2_x3_x5_xm 0 x2_ckb x2_ck x2_vbn cml_latch
x2_x3_x5_xs x2_x3_q5 x2_x3_q5b x2_x3_x5_m x2_x3_x5_mb vdd_x2_x3_x5_xs 0 x2_ck x2_ckb x2_vbn cml_latch
x2_x3_x1_xm x2_x3_x1_m x2_x3_x1_mb eq_p eq_m vdd_x2_x3_x1_xm 0 x2_ck x2_ckb x2_vbn cml_latch
x2_x3_x1_xs x2_x3_q1 x2_x3_q1b x2_x3_x1_m x2_x3_x1_mb vdd_x2_x3_x1_xs 0 x2_ckb x2_ck x2_vbn cml_latch
x2_x3_x2_xm x2_x3_x2_m x2_x3_x2_mb x2_x3_q5 x2_x3_q5b vdd_x2_x3_x2_xm 0 x2_ckb x2_ck x2_vbn cml_latch
x2_x3_x2_xs x2_x3_q2 x2_x3_q2b x2_x3_x2_m x2_x3_x2_mb vdd_x2_x3_x2_xs 0 x2_ck x2_ckb x2_vbn cml_latch
x2_x3_x3_xm x2_x3_x3_m x2_x3_x3_mb x2_x3_q1 x2_x3_q1b vdd_x2_x3_x3_xm 0 x2_ckb x2_ck x2_vbn cml_latch
x2_x3_x3_xs x2_x3_b x2_x3_bb x2_x3_x3_m x2_x3_x3_mb vdd_x2_x3_x3_xs 0 x2_ck x2_ckb x2_vbn cml_latch
x2_x3_xc5 x2_x3_a5 x2_x3_q5 x2_x3_q5b vdd_x2_x3_xc5 0 x2_vbn cml2cmos_w2
x2_x3_xc2 x2_x3_a2 x2_x3_q2 x2_x3_q2b vdd_x2_x3_xc2 0 x2_vbn cml2cmos_w2
x2_x3_xcb x2_x3_bp x2_x3_b x2_x3_bb vdd_x2_x3_xcb 0 x2_vbn cml2cmos_w2
x2_x3_x6 x2_x3_a5 x2_x3_bp x2_net3 vdd_x2_x3_x6 0 cx_xor
x2_x3_x7 x2_x3_a2 x2_x3_bp x2_net2 vdd_x2_x3_x7 0 cx_xor
x2_x11 rclk_p x2_ck x2_ckb vdd_x2_x11 0 x2_vbn cml2cmos
x2_x12 rclk_m x2_ckb x2_ck vdd_x2_x12 0 x2_vbn cml2cmos
x2_x20 vdd_x2_x20 0 x2_net1 vctrl_precharge
x3 vdd_x3 0 rclk_p clkout_p inverter_chain
x4 vdd_x4 0 rclk_m clkout_n inverter_chain
.ic v(x2_x20.nrc)=0
.control
  save i(Vx1) i(Vx2_x6) i(Vx2_x8) i(Vx2_x2) i(Vx2_x1_x1) i(Vx2_x1_x2) i(Vx2_x1_x3) i(Vx2_x1_x5) i(Vx2_x1_x4) i(Vx2_x9) i(Vx2_xref) i(Vx2_x3_x5_xm) i(Vx2_x3_x5_xs) i(Vx2_x3_x1_xm) i(Vx2_x3_x1_xs) i(Vx2_x3_x2_xm) i(Vx2_x3_x2_xs) i(Vx2_x3_x3_xm) i(Vx2_x3_x3_xs) i(Vx2_x3_xc5) i(Vx2_x3_xc2) i(Vx2_x3_xcb) i(Vx2_x3_x6) i(Vx2_x3_x7) i(Vx2_x11) i(Vx2_x12) i(Vx2_x20) i(Vx3) i(Vx4) i(Vtie) i(Vtail) v(x2_net1) v(clkout_p) v(x2_net2) v(x2_net3) v(x2_x2.cap_plus) v(rclk_p) v(eq_p) v(eq_m)
  tran 20p 3000n
  meas tran vx1 avg i(Vx1) from=2600n to=3000n
  meas tran vx2_x6 avg i(Vx2_x6) from=2600n to=3000n
  meas tran vx2_x8 avg i(Vx2_x8) from=2600n to=3000n
  meas tran vx2_x2 avg i(Vx2_x2) from=2600n to=3000n
  meas tran vx2_x1_x1 avg i(Vx2_x1_x1) from=2600n to=3000n
  meas tran vx2_x1_x2 avg i(Vx2_x1_x2) from=2600n to=3000n
  meas tran vx2_x1_x3 avg i(Vx2_x1_x3) from=2600n to=3000n
  meas tran vx2_x1_x5 avg i(Vx2_x1_x5) from=2600n to=3000n
  meas tran vx2_x1_x4 avg i(Vx2_x1_x4) from=2600n to=3000n
  meas tran vx2_x9 avg i(Vx2_x9) from=2600n to=3000n
  meas tran vx2_xref avg i(Vx2_xref) from=2600n to=3000n
  meas tran vx2_x3_x5_xm avg i(Vx2_x3_x5_xm) from=2600n to=3000n
  meas tran vx2_x3_x5_xs avg i(Vx2_x3_x5_xs) from=2600n to=3000n
  meas tran vx2_x3_x1_xm avg i(Vx2_x3_x1_xm) from=2600n to=3000n
  meas tran vx2_x3_x1_xs avg i(Vx2_x3_x1_xs) from=2600n to=3000n
  meas tran vx2_x3_x2_xm avg i(Vx2_x3_x2_xm) from=2600n to=3000n
  meas tran vx2_x3_x2_xs avg i(Vx2_x3_x2_xs) from=2600n to=3000n
  meas tran vx2_x3_x3_xm avg i(Vx2_x3_x3_xm) from=2600n to=3000n
  meas tran vx2_x3_x3_xs avg i(Vx2_x3_x3_xs) from=2600n to=3000n
  meas tran vx2_x3_xc5 avg i(Vx2_x3_xc5) from=2600n to=3000n
  meas tran vx2_x3_xc2 avg i(Vx2_x3_xc2) from=2600n to=3000n
  meas tran vx2_x3_xcb avg i(Vx2_x3_xcb) from=2600n to=3000n
  meas tran vx2_x3_x6 avg i(Vx2_x3_x6) from=2600n to=3000n
  meas tran vx2_x3_x7 avg i(Vx2_x3_x7) from=2600n to=3000n
  meas tran vx2_x11 avg i(Vx2_x11) from=2600n to=3000n
  meas tran vx2_x12 avg i(Vx2_x12) from=2600n to=3000n
  meas tran vx2_x20 avg i(Vx2_x20) from=2600n to=3000n
  meas tran vx3 avg i(Vx3) from=2600n to=3000n
  meas tran vx4 avg i(Vx4) from=2600n to=3000n
  meas tran vtie avg i(Vtie) from=2600n to=3000n
  meas tran vtailcur avg i(Vtail) from=2600n to=3000n
  meas tran vctrl_a avg v(x2_net1) from=2600n to=3000n
  meas tran vctrl_b avg v(x2_net1) from=2600n to=3000n
  meas tran vctrl_pp pp v(x2_net1) from=2600n to=3000n
  meas tran e_a when v(clkout_p)=0.9 rise=1 td=2600n
  meas tran e_b when v(clkout_p)=0.9 rise=201 td=2600n
  let f_mhz = 200/(e_b-e_a)/1e6
  print f_mhz
  meas tran up_duty avg v(x2_net2) from=2600n to=3000n
  meas tran dn_duty avg v(x2_net3) from=2600n to=3000n
  let rclkp = v(rclk_p)
  let coutp = v(eq_p)
  let coutm = v(eq_m)
  set filetype=ascii
  write ss_typ_m40C_1p80V_chain.raw rclkp coutp coutm
  wrdata ss_typ_m40C_1p80V.dat v(x2_net1) v(x2_x2.cap_plus) v(x2_net2) v(x2_net3) v(rclk_p)
.endc
.end
