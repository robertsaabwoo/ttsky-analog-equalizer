* SUITE cml_full fs_typ_27C_1p80V: cold start, 3000 ns
* GENERATED by gen_cml.py -- do not edit.
* S3_full (cx3w PD + cml_bias + cml_clkbuf + cp_bias + scaled filter, vtail=0.85): the CML CDR, closed loop, same stimulus and
* window as power/P0_chain (PRBS7, 200 mVpp, 500 ohm / 5 pF pad, cload 50f).
* Every leaf cell has its own supply source.
* Leaf devices instantiated: 198
* SRC vx1 x1:CTLE
* SRC vx2_x6 x2:CDR_cml_cx/x6:tiny_pll_charge_pump
* SRC vx2_x8 x2:CDR_cml_cx/x8:cp_bias
* SRC vx2_x2 x2:CDR_cml_cx/x2:tiny_pll_loop_filter
* SRC vx2_x1_x1 x2:CDR_cml_cx/x1:ring_core/x1:ring_inverter
* SRC vx2_x1_x2 x2:CDR_cml_cx/x1:ring_core/x2:ring_inverter
* SRC vx2_x1_x3 x2:CDR_cml_cx/x1:ring_core/x3:ring_inverter
* SRC vx2_x1_x5 x2:CDR_cml_cx/x1:ring_core/x5:ring_inverter
* SRC vx2_x1_x4 x2:CDR_cml_cx/x1:ring_core/x4:ring_inverter
* SRC vx2_x9 x2:CDR_cml_cx/x9:cml_clkbuf
* SRC vx2_xref x2:CDR_cml_cx/xref:cml_bias
* SRC vx2_x3_x5_xm x2:CDR_cml_cx/x3:cml_pd_cx3w/x5:cml_dff/xm:cml_latch
* SRC vx2_x3_x5_xs x2:CDR_cml_cx/x3:cml_pd_cx3w/x5:cml_dff/xs:cml_latch
* SRC vx2_x3_x1_xm x2:CDR_cml_cx/x3:cml_pd_cx3w/x1:cml_dff/xm:cml_latch
* SRC vx2_x3_x1_xs x2:CDR_cml_cx/x3:cml_pd_cx3w/x1:cml_dff/xs:cml_latch
* SRC vx2_x3_x2_xm x2:CDR_cml_cx/x3:cml_pd_cx3w/x2:cml_dff/xm:cml_latch
* SRC vx2_x3_x2_xs x2:CDR_cml_cx/x3:cml_pd_cx3w/x2:cml_dff/xs:cml_latch
* SRC vx2_x3_x3_xm x2:CDR_cml_cx/x3:cml_pd_cx3w/x3:cml_dff/xm:cml_latch
* SRC vx2_x3_x3_xs x2:CDR_cml_cx/x3:cml_pd_cx3w/x3:cml_dff/xs:cml_latch
* SRC vx2_x3_xc5 x2:CDR_cml_cx/x3:cml_pd_cx3w/xc5:cml2cmos_w2
* SRC vx2_x3_xc2 x2:CDR_cml_cx/x3:cml_pd_cx3w/xc2:cml2cmos_w2
* SRC vx2_x3_xcb x2:CDR_cml_cx/x3:cml_pd_cx3w/xcb:cml2cmos_w2
* SRC vx2_x3_x6 x2:CDR_cml_cx/x3:cml_pd_cx3w/x6:cx_xor
* SRC vx2_x3_x7 x2:CDR_cml_cx/x3:cml_pd_cx3w/x7:cx_xor
* SRC vx2_x11 x2:CDR_cml_cx/x11:cml2cmos
* SRC vx2_x12 x2:CDR_cml_cx/x12:cml2cmos
* SRC vx2_x20 x2:CDR_cml_cx/x20:vctrl_precharge
* SRC vx3 x3:inverter_chain
* SRC vx4 x4:inverter_chain
* corner: mos=fs rc=typ temp=27C
.param mc_mm_switch=0
.param mc_pr_switch=0
.include "/home/ttuser/pdk/sky130A/libs.tech/ngspice/corners/fs.spice"
.include "/home/ttuser/pdk/sky130A/libs.tech/ngspice/r+c/res_typical__cap_typical.spice"
.include "/home/ttuser/pdk/sky130A/libs.tech/ngspice/r+c/res_typical__cap_typical__lin.spice"
.include "/home/ttuser/pdk/sky130A/libs.tech/ngspice/corners/fs/specialized_cells.spice"
.temp 27

.include /home/ttuser/pdk/sky130A/libs.ref/sky130_fd_sc_hd/spice/sky130_fd_sc_hd.spice
.include /home/ttuser/ssh_analog/ttsky-analog-equalizer/xschem/tuning/vw/frozen_scaled.inc
.include /home/ttuser/ssh_analog/ttsky-analog-equalizer/xschem/tuning/cml/.netlists/cml_cells.inc
.include /home/ttuser/ssh_analog/ttsky-analog-equalizer/xschem/tuning/vw/cx_cells.inc
.include /home/ttuser/ssh_analog/ttsky-analog-equalizer/xschem/tuning/vw/bias/cml_bias.inc
.include /home/ttuser/ssh_analog/ttsky-analog-equalizer/xschem/tuning/vw/bias/cml_clkbuf.inc
.include /home/ttuser/ssh_analog/ttsky-analog-equalizer/xschem/tuning/vw/bias/cp_bias.inc
.include /home/ttuser/ssh_analog/ttsky-analog-equalizer/xschem/tuning/vw/S3_full_top.inc
.include /home/ttuser/ssh_analog/ttsky-analog-equalizer/xschem/tuning/e2e_prbs6u.inc
.options method=gear reltol=0.001 abstol=1e-12
.param vcm=0.9 amp=0.2 rpad=500 cpad=5p
Vx1 vdd_x1 0 1.8
Vx2_x6 vdd_x2_x6 0 1.8
Vx2_x8 vdd_x2_x8 0 1.8
Vx2_x2 vdd_x2_x2 0 1.8
Vx2_x1_x1 vdd_x2_x1_x1 0 1.8
Vx2_x1_x2 vdd_x2_x1_x2 0 1.8
Vx2_x1_x3 vdd_x2_x1_x3 0 1.8
Vx2_x1_x5 vdd_x2_x1_x5 0 1.8
Vx2_x1_x4 vdd_x2_x1_x4 0 1.8
Vx2_x9 vdd_x2_x9 0 1.8
Vx2_xref vdd_x2_xref 0 1.8
Vx2_x3_x5_xm vdd_x2_x3_x5_xm 0 1.8
Vx2_x3_x5_xs vdd_x2_x3_x5_xs 0 1.8
Vx2_x3_x1_xm vdd_x2_x3_x1_xm 0 1.8
Vx2_x3_x1_xs vdd_x2_x3_x1_xs 0 1.8
Vx2_x3_x2_xm vdd_x2_x3_x2_xm 0 1.8
Vx2_x3_x2_xs vdd_x2_x3_x2_xs 0 1.8
Vx2_x3_x3_xm vdd_x2_x3_x3_xm 0 1.8
Vx2_x3_x3_xs vdd_x2_x3_x3_xs 0 1.8
Vx2_x3_xc5 vdd_x2_x3_xc5 0 1.8
Vx2_x3_xc2 vdd_x2_x3_xc2 0 1.8
Vx2_x3_xcb vdd_x2_x3_xcb 0 1.8
Vx2_x3_x6 vdd_x2_x3_x6 0 1.8
Vx2_x3_x7 vdd_x2_x3_x7 0 1.8
Vx2_x11 vdd_x2_x11 0 1.8
Vx2_x12 vdd_x2_x12 0 1.8
Vx2_x20 vdd_x2_x20 0 1.8
Vx3 vdd_x3 0 1.8
Vx4 vdd_x4 0 1.8
Vtie vtie 0 1.8
Vtail vtail 0 0.85
Vb  vbias 0 0.9
Edinp dinp 0 vol='vcm + 0.5*amp*(v(dsrc)-0.5)'
Edinm dinm 0 vol='vcm - 0.5*amp*(v(dsrc)-0.5)'
Rpadp dinp cinp 'rpad'
Cpadp cinp 0    'cpad'
Rpadm dinm cinm 'rpad'
Cpadm cinm 0    'cpad'
Clp clkout_p 0 50f
Cln clkout_n 0 50f
x2_x8 vdd_x2_x8 0 x2_bias_n x2_bias_p cp_bias
x2_x1_x1 vdd_x2_x1_x1 0 x2_t7 x2_x1_n1 x2_t8 x2_x1_n2 x2_net1 ring_inverter
x2_x1_x2 vdd_x2_x1_x2 0 x2_x1_n1 x2_x1_n4 x2_x1_n2 x2_x1_n3 x2_net1 ring_inverter
x2_x1_x3 vdd_x2_x1_x3 0 x2_x1_n4 x2_x1_n5 x2_x1_n3 x2_x1_n6 x2_net1 ring_inverter
x2_x1_x5 vdd_x2_x1_x5 0 x2_x1_n5 x2_x1_n9 x2_x1_n6 x2_x1_n10 x2_net1 ring_inverter
x2_x1_x4 vdd_x2_x1_x4 0 x2_x1_n9 x2_t7 x2_x1_n10 x2_t8 x2_net1 ring_inverter
x2_x9 vdd_x2_x9 0 x2_ck x2_ckb x2_t7 x2_t8 x2_vbn cml_clkbuf
x2_xref vdd_x2_xref 0 x2_vbn cml_bias
x2_x3_x5_xm x2_x3_x5_m x2_x3_x5_mb eq_p eq_m vdd_x2_x3_x5_xm 0 x2_ckb x2_ck x2_vbn cml_latch
x2_x3_x5_xs x2_x3_q5 x2_x3_q5b x2_x3_x5_m x2_x3_x5_mb vdd_x2_x3_x5_xs 0 x2_ck x2_ckb x2_vbn cml_latch
x2_x3_x1_xm x2_x3_x1_m x2_x3_x1_mb eq_p eq_m vdd_x2_x3_x1_xm 0 x2_ck x2_ckb x2_vbn cml_latch
x2_x3_x1_xs x2_x3_q1 x2_x3_q1b x2_x3_x1_m x2_x3_x1_mb vdd_x2_x3_x1_xs 0 x2_ckb x2_ck x2_vbn cml_latch
x2_x3_x2_xm x2_x3_x2_m x2_x3_x2_mb x2_x3_q5 x2_x3_q5b vdd_x2_x3_x2_xm 0 x2_ckb x2_ck x2_vbn cml_latch
x2_x3_x2_xs x2_x3_q2 x2_x3_q2b x2_x3_x2_m x2_x3_x2_mb vdd_x2_x3_x2_xs 0 x2_ck x2_ckb x2_vbn cml_latch
x2_x3_x3_xm x2_x3_x3_m x2_x3_x3_mb x2_x3_q1 x2_x3_q1b vdd_x2_x3_x3_xm 0 x2_ckb x2_ck x2_vbn cml_latch
x2_x3_x3_xs x2_x3_b x2_x3_bb x2_x3_x3_m x2_x3_x3_mb vdd_x2_x3_x3_xs 0 x2_ck x2_ckb x2_vbn cml_latch
x2_x3_xc5 x2_x3_a5 x2_x3_q5 x2_x3_q5b vdd_x2_x3_xc5 0 x2_vbn cml2cmos_w2
x2_x3_xc2 x2_x3_a2 x2_x3_q2 x2_x3_q2b vdd_x2_x3_xc2 0 x2_vbn cml2cmos_w2
x2_x3_xcb x2_x3_bp x2_x3_b x2_x3_bb vdd_x2_x3_xcb 0 x2_vbn cml2cmos_w2
x2_x3_x6 x2_x3_a5 x2_x3_bp x2_net3 vdd_x2_x3_x6 0 cx_xor
x2_x3_x7 x2_x3_a2 x2_x3_bp x2_net2 vdd_x2_x3_x7 0 cx_xor
x2_x11 rclk_p x2_ck x2_ckb vdd_x2_x11 0 x2_vbn cml2cmos
x2_x12 rclk_m x2_ckb x2_ck vdd_x2_x12 0 x2_vbn cml2cmos
x3 vdd_x3 0 rclk_p clkout_p inverter_chain
x4 vdd_x4 0 rclk_m clkout_n inverter_chain
* R1: ideal vctrl in place of pump + filter + precharge; CTLE -> DC
Vctl x2_net1 0 0.79
Veqp eq_p 0 1.25
Veqm eq_m 0 1.05
.ic v(x2_t7)=1.8 v(x2_t8)=0
.control
  save v(x2_t7) v(x2_t8)
  alter Vctl dc=0.7
  tran 10p 110n uic
  meas tran v0p70_a when v(x2_t7)=v(x2_t8) rise=10
  meas tran v0p70_b when v(x2_t7)=v(x2_t8) rise=40
  alter Vctl dc=0.75
  tran 10p 110n uic
  meas tran v0p75_a when v(x2_t7)=v(x2_t8) rise=10
  meas tran v0p75_b when v(x2_t7)=v(x2_t8) rise=40
  alter Vctl dc=0.79
  tran 10p 110n uic
  meas tran v0p79_a when v(x2_t7)=v(x2_t8) rise=10
  meas tran v0p79_b when v(x2_t7)=v(x2_t8) rise=40
  alter Vctl dc=0.85
  tran 10p 110n uic
  meas tran v0p85_a when v(x2_t7)=v(x2_t8) rise=10
  meas tran v0p85_b when v(x2_t7)=v(x2_t8) rise=40
  alter Vctl dc=0.9
  tran 10p 110n uic
  meas tran v0p90_a when v(x2_t7)=v(x2_t8) rise=10
  meas tran v0p90_b when v(x2_t7)=v(x2_t8) rise=40
  alter Vctl dc=1.0
  tran 10p 110n uic
  meas tran v1p00_a when v(x2_t7)=v(x2_t8) rise=10
  meas tran v1p00_b when v(x2_t7)=v(x2_t8) rise=40
  alter Vctl dc=1.1
  tran 10p 110n uic
  meas tran v1p10_a when v(x2_t7)=v(x2_t8) rise=10
  meas tran v1p10_b when v(x2_t7)=v(x2_t8) rise=40
.endc
.end
