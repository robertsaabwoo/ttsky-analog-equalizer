* SUITE frozen tt_typ_27C_1p98V: cold start, 3000 ns
* GENERATED by gen_power.py -- do not edit; re-run the generator.
* Power analysis of the frozen ctle_cdr_rx macro, tt / 27 C / 1.8 V.
* See ../POWER.md for what each number means.
* P0: whole macro, closed loop, PRBS7 at 600.6 Mb/s, 200 mVpp diff, CM 0.9 V,
* through the TT analog pin model (500 ohm / 5 pF per leg) -- the C23/C25 setup.
* Every leaf cell has its own 1.8 V source; the source -> cell map is below.
* Output pins loaded with cload = 50f each (an ASSUMPTION: the uo_out load
* is not documented anywhere in the repo; see POWER.md for the scaling).
* Leaf devices instantiated: 223
* SRC vx1 x1:CTLE
* SRC vx2_x6 x2:CDR/x6:tiny_pll_charge_pump
* SRC vx2_x8 x2:CDR/x8:tiny_pll_bias_gen
* SRC vx2_x2 x2:CDR/x2:tiny_pll_loop_filter
* SRC vx2_x3_x6 x2:CDR/x3:alexander_phase_detector/x6:robs_xor
* SRC vx2_x3_x7 x2:CDR/x3:alexander_phase_detector/x7:robs_xor
* SRC vx2_x3_x5_x1 x2:CDR/x3:alexander_phase_detector/x5:d_flip_flop/x1:d_latch
* SRC vx2_x3_x5_x1_i x2:CDR/x3:alexander_phase_detector/x5:d_flip_flop/x1:d_latch [output inverters]
* SRC vx2_x3_x5_x2 x2:CDR/x3:alexander_phase_detector/x5:d_flip_flop/x2:d_latch
* SRC vx2_x3_x5_x2_i x2:CDR/x3:alexander_phase_detector/x5:d_flip_flop/x2:d_latch [output inverters]
* SRC vx2_x3_x1_x1 x2:CDR/x3:alexander_phase_detector/x1:d_flip_flop/x1:d_latch
* SRC vx2_x3_x1_x1_i x2:CDR/x3:alexander_phase_detector/x1:d_flip_flop/x1:d_latch [output inverters]
* SRC vx2_x3_x1_x2 x2:CDR/x3:alexander_phase_detector/x1:d_flip_flop/x2:d_latch
* SRC vx2_x3_x1_x2_i x2:CDR/x3:alexander_phase_detector/x1:d_flip_flop/x2:d_latch [output inverters]
* SRC vx2_x3_x2_x1 x2:CDR/x3:alexander_phase_detector/x2:d_flip_flop/x1:d_latch
* SRC vx2_x3_x2_x1_i x2:CDR/x3:alexander_phase_detector/x2:d_flip_flop/x1:d_latch [output inverters]
* SRC vx2_x3_x2_x2 x2:CDR/x3:alexander_phase_detector/x2:d_flip_flop/x2:d_latch
* SRC vx2_x3_x2_x2_i x2:CDR/x3:alexander_phase_detector/x2:d_flip_flop/x2:d_latch [output inverters]
* SRC vx2_x3_x3_x1 x2:CDR/x3:alexander_phase_detector/x3:d_flip_flop/x1:d_latch
* SRC vx2_x3_x3_x1_i x2:CDR/x3:alexander_phase_detector/x3:d_flip_flop/x1:d_latch [output inverters]
* SRC vx2_x3_x3_x2 x2:CDR/x3:alexander_phase_detector/x3:d_flip_flop/x2:d_latch
* SRC vx2_x3_x3_x2_i x2:CDR/x3:alexander_phase_detector/x3:d_flip_flop/x2:d_latch [output inverters]
* SRC vx2_x1_x1 x2:CDR/x1:ring_oscillator/x1:ring_inverter
* SRC vx2_x1_x2 x2:CDR/x1:ring_oscillator/x2:ring_inverter
* SRC vx2_x1_x3 x2:CDR/x1:ring_oscillator/x3:ring_inverter
* SRC vx2_x1_x5 x2:CDR/x1:ring_oscillator/x5:ring_inverter
* SRC vx2_x1_x4 x2:CDR/x1:ring_oscillator/x4:ring_inverter
* SRC vx2_x1_x6 x2:CDR/x1:ring_oscillator/x6:diff_amp_inv
* SRC vx2_x4 x2:CDR/x4:diff_amp_inv
* SRC vx2_x11 x2:CDR/x11:inverter_buffer
* SRC vx2_x12 x2:CDR/x12:single_inverter
* SRC vx2_x20 x2:CDR/x20:vctrl_precharge
* SRC vx3 x3:inverter_chain
* SRC vx4 x4:inverter_chain
* corner: mos=tt rc=typ temp=27C
.param mc_mm_switch=0
.param mc_pr_switch=0
.include "/home/ttuser/pdk/sky130A/libs.tech/ngspice/corners/tt.spice"
.include "/home/ttuser/pdk/sky130A/libs.tech/ngspice/r+c/res_typical__cap_typical.spice"
.include "/home/ttuser/pdk/sky130A/libs.tech/ngspice/r+c/res_typical__cap_typical__lin.spice"
.include "/home/ttuser/pdk/sky130A/libs.tech/ngspice/corners/tt/specialized_cells.spice"
.temp 27

.include /home/ttuser/pdk/sky130A/libs.ref/sky130_fd_sc_hd/spice/sky130_fd_sc_hd.spice
.include /home/ttuser/ssh_analog/ttsky-analog-equalizer/xschem/tuning/power/.netlists/subckts.inc
.include /home/ttuser/ssh_analog/ttsky-analog-equalizer/xschem/tuning/e2e_prbs6u.inc
.options method=gear reltol=0.001 abstol=1e-12
.param vcm=0.9 amp=0.2 rpad=500 cpad=5p
Vx1 vdd_x1 0 1.98
Vx2_x6 vdd_x2_x6 0 1.98
Vx2_x8 vdd_x2_x8 0 1.98
Vx2_x2 vdd_x2_x2 0 1.98
Vx2_x3_x6 vdd_x2_x3_x6 0 1.98
Vx2_x3_x7 vdd_x2_x3_x7 0 1.98
Vx2_x3_x5_x1 vdd_x2_x3_x5_x1 0 1.98
Vx2_x3_x5_x1_i vddi_x2_x3_x5_x1 0 1.98
Vx2_x3_x5_x2 vdd_x2_x3_x5_x2 0 1.98
Vx2_x3_x5_x2_i vddi_x2_x3_x5_x2 0 1.98
Vx2_x3_x1_x1 vdd_x2_x3_x1_x1 0 1.98
Vx2_x3_x1_x1_i vddi_x2_x3_x1_x1 0 1.98
Vx2_x3_x1_x2 vdd_x2_x3_x1_x2 0 1.98
Vx2_x3_x1_x2_i vddi_x2_x3_x1_x2 0 1.98
Vx2_x3_x2_x1 vdd_x2_x3_x2_x1 0 1.98
Vx2_x3_x2_x1_i vddi_x2_x3_x2_x1 0 1.98
Vx2_x3_x2_x2 vdd_x2_x3_x2_x2 0 1.98
Vx2_x3_x2_x2_i vddi_x2_x3_x2_x2 0 1.98
Vx2_x3_x3_x1 vdd_x2_x3_x3_x1 0 1.98
Vx2_x3_x3_x1_i vddi_x2_x3_x3_x1 0 1.98
Vx2_x3_x3_x2 vdd_x2_x3_x3_x2 0 1.98
Vx2_x3_x3_x2_i vddi_x2_x3_x3_x2 0 1.98
Vx2_x1_x1 vdd_x2_x1_x1 0 1.98
Vx2_x1_x2 vdd_x2_x1_x2 0 1.98
Vx2_x1_x3 vdd_x2_x1_x3 0 1.98
Vx2_x1_x5 vdd_x2_x1_x5 0 1.98
Vx2_x1_x4 vdd_x2_x1_x4 0 1.98
Vx2_x1_x6 vdd_x2_x1_x6 0 1.98
Vx2_x4 vdd_x2_x4 0 1.98
Vx2_x11 vdd_x2_x11 0 1.98
Vx2_x12 vdd_x2_x12 0 1.98
Vx2_x20 vdd_x2_x20 0 1.98
Vx3 vdd_x3 0 1.98
Vx4 vdd_x4 0 1.98
* VDPWR used as a logic tie (bias_gen en, diff_amp_inv vctrl) -- not a supply
Vtie vtie 0 1.98
Vb  vbias 0 0.9
Edinp dinp 0 vol='vcm + 0.5*amp*(v(dsrc)-0.5)'
Edinm dinm 0 vol='vcm - 0.5*amp*(v(dsrc)-0.5)'
Rpadp dinp cinp 'rpad'
Cpadp cinp 0    'cpad'
Rpadm dinm cinm 'rpad'
Cpadm cinm 0    'cpad'
Clp clkout_p 0 50f
Cln clkout_n 0 50f
x1 eq_p eq_m cinp cinm vdd_x1 0 vbias CTLE
x2_x6 vdd_x2_x6 vdd_x2_x6 0 0 x2_net1 x2_net2 x2_net3 x2_bias_n x2_bias_p tiny_pll_charge_pump
x2_x8 0 0 vdd_x2_x8 vdd_x2_x8 x2_bias_n vtie 0 x2_bias_p tiny_pll_bias_gen
x2_x2 0 0 vdd_x2_x2 vdd_x2_x2 x2_net1 tiny_pll_loop_filter
x2_x3_x6 x2_x3_net1 vdd_x2_x3_x6 x2_x3_Bm 0 x2_net3 x2_x3_net2 x2_x3_Bp robs_xor
x2_x3_x7 x2_x3_net5 vdd_x2_x3_x7 x2_x3_Bm 0 x2_net2 x2_x3_net6 x2_x3_Bp robs_xor
x2_x3_x5_x1 x2_x3_x5_net1 x2_x3_x5_net2 eq_p eq_m vdd_x2_x3_x5_x1 0 rclk_m rclk_p vbias vddi_x2_x3_x5_x1 d_latch__split
x2_x3_x5_x2 x2_x3_net1 x2_x3_net2 x2_x3_x5_net1 x2_x3_x5_net2 vdd_x2_x3_x5_x2 0 rclk_p rclk_m vbias vddi_x2_x3_x5_x2 d_latch__split
x2_x3_x1_x1 x2_x3_x1_net1 x2_x3_x1_net2 eq_p eq_m vdd_x2_x3_x1_x1 0 rclk_p rclk_m vbias vddi_x2_x3_x1_x1 d_latch__split
x2_x3_x1_x2 x2_x3_net3 x2_x3_net4 x2_x3_x1_net1 x2_x3_x1_net2 vdd_x2_x3_x1_x2 0 rclk_m rclk_p vbias vddi_x2_x3_x1_x2 d_latch__split
x2_x3_x2_x1 x2_x3_x2_net1 x2_x3_x2_net2 x2_x3_net1 x2_x3_net2 vdd_x2_x3_x2_x1 0 rclk_m rclk_p vbias vddi_x2_x3_x2_x1 d_latch__split
x2_x3_x2_x2 x2_x3_net5 x2_x3_net6 x2_x3_x2_net1 x2_x3_x2_net2 vdd_x2_x3_x2_x2 0 rclk_p rclk_m vbias vddi_x2_x3_x2_x2 d_latch__split
x2_x3_x3_x1 x2_x3_x3_net1 x2_x3_x3_net2 x2_x3_net3 x2_x3_net4 vdd_x2_x3_x3_x1 0 rclk_m rclk_p vbias vddi_x2_x3_x3_x1 d_latch__split
x2_x3_x3_x2 x2_x3_Bp x2_x3_Bm x2_x3_x3_net1 x2_x3_x3_net2 vdd_x2_x3_x3_x2 0 rclk_p rclk_m vbias vddi_x2_x3_x3_x2 d_latch__split
x2_x1_x1 vdd_x2_x1_x1 0 x2_x1_net7 x2_x1_net1 x2_x1_net8 x2_x1_net2 x2_net1 ring_inverter
x2_x1_x2 vdd_x2_x1_x2 0 x2_x1_net1 x2_x1_net4 x2_x1_net2 x2_x1_net3 x2_net1 ring_inverter
x2_x1_x3 vdd_x2_x1_x3 0 x2_x1_net4 x2_x1_net5 x2_x1_net3 x2_x1_net6 x2_net1 ring_inverter
x2_x1_x5 vdd_x2_x1_x5 0 x2_x1_net5 x2_x1_net9 x2_x1_net6 x2_x1_net10 x2_net1 ring_inverter
x2_x1_x4 vdd_x2_x1_x4 0 x2_x1_net9 x2_x1_net7 x2_x1_net10 x2_x1_net8 x2_net1 ring_inverter
x2_x1_x6 vdd_x2_x1_x6 0 x2_net5 x2_net4 x2_x1_net7 x2_x1_net8 vtie diff_amp_inv
x2_x4 vdd_x2_x4 0 x2_clkrawm x2_clkrawp x2_net4 x2_net5 vtie diff_amp_inv
x2_x11 vdd_x2_x11 0 x2_clkrawp rclk_p inverter_buffer
x2_x12 vdd_x2_x12 0 rclk_p rclk_m single_inverter
x2_x20 vdd_x2_x20 0 x2_net1 vctrl_precharge
x3 vdd_x3 0 rclk_p clkout_p inverter_chain
x4 vdd_x4 0 rclk_m clkout_n inverter_chain
* .op treats a capacitor as an open, so the precharge one-shot is dead without
* this (NOTES.md §19)
.ic v(x2_x20.nrc)=0
.control
  save i(Vx1) i(Vx2_x6) i(Vx2_x8) i(Vx2_x2) i(Vx2_x3_x6) i(Vx2_x3_x7) i(Vx2_x3_x5_x1) i(Vx2_x3_x5_x1_i) i(Vx2_x3_x5_x2) i(Vx2_x3_x5_x2_i) i(Vx2_x3_x1_x1) i(Vx2_x3_x1_x1_i) i(Vx2_x3_x1_x2) i(Vx2_x3_x1_x2_i) i(Vx2_x3_x2_x1) i(Vx2_x3_x2_x1_i) i(Vx2_x3_x2_x2) i(Vx2_x3_x2_x2_i) i(Vx2_x3_x3_x1) i(Vx2_x3_x3_x1_i) i(Vx2_x3_x3_x2) i(Vx2_x3_x3_x2_i) i(Vx2_x1_x1) i(Vx2_x1_x2) i(Vx2_x1_x3) i(Vx2_x1_x5) i(Vx2_x1_x4) i(Vx2_x1_x6) i(Vx2_x4) i(Vx2_x11) i(Vx2_x12) i(Vx2_x20) i(Vx3) i(Vx4) i(Vtie) i(Vb) v(x2_net1) v(clkout_p) v(x2_net2) v(x2_net3) v(x2_x2.cap_plus) v(rclk_p) v(eq_p) v(eq_m)
  tran 20p 3000n
  meas tran vx1 avg i(Vx1) from=2600n to=3000n
  meas tran vx2_x6 avg i(Vx2_x6) from=2600n to=3000n
  meas tran vx2_x8 avg i(Vx2_x8) from=2600n to=3000n
  meas tran vx2_x2 avg i(Vx2_x2) from=2600n to=3000n
  meas tran vx2_x3_x6 avg i(Vx2_x3_x6) from=2600n to=3000n
  meas tran vx2_x3_x7 avg i(Vx2_x3_x7) from=2600n to=3000n
  meas tran vx2_x3_x5_x1 avg i(Vx2_x3_x5_x1) from=2600n to=3000n
  meas tran vx2_x3_x5_x1_i avg i(Vx2_x3_x5_x1_i) from=2600n to=3000n
  meas tran vx2_x3_x5_x2 avg i(Vx2_x3_x5_x2) from=2600n to=3000n
  meas tran vx2_x3_x5_x2_i avg i(Vx2_x3_x5_x2_i) from=2600n to=3000n
  meas tran vx2_x3_x1_x1 avg i(Vx2_x3_x1_x1) from=2600n to=3000n
  meas tran vx2_x3_x1_x1_i avg i(Vx2_x3_x1_x1_i) from=2600n to=3000n
  meas tran vx2_x3_x1_x2 avg i(Vx2_x3_x1_x2) from=2600n to=3000n
  meas tran vx2_x3_x1_x2_i avg i(Vx2_x3_x1_x2_i) from=2600n to=3000n
  meas tran vx2_x3_x2_x1 avg i(Vx2_x3_x2_x1) from=2600n to=3000n
  meas tran vx2_x3_x2_x1_i avg i(Vx2_x3_x2_x1_i) from=2600n to=3000n
  meas tran vx2_x3_x2_x2 avg i(Vx2_x3_x2_x2) from=2600n to=3000n
  meas tran vx2_x3_x2_x2_i avg i(Vx2_x3_x2_x2_i) from=2600n to=3000n
  meas tran vx2_x3_x3_x1 avg i(Vx2_x3_x3_x1) from=2600n to=3000n
  meas tran vx2_x3_x3_x1_i avg i(Vx2_x3_x3_x1_i) from=2600n to=3000n
  meas tran vx2_x3_x3_x2 avg i(Vx2_x3_x3_x2) from=2600n to=3000n
  meas tran vx2_x3_x3_x2_i avg i(Vx2_x3_x3_x2_i) from=2600n to=3000n
  meas tran vx2_x1_x1 avg i(Vx2_x1_x1) from=2600n to=3000n
  meas tran vx2_x1_x2 avg i(Vx2_x1_x2) from=2600n to=3000n
  meas tran vx2_x1_x3 avg i(Vx2_x1_x3) from=2600n to=3000n
  meas tran vx2_x1_x5 avg i(Vx2_x1_x5) from=2600n to=3000n
  meas tran vx2_x1_x4 avg i(Vx2_x1_x4) from=2600n to=3000n
  meas tran vx2_x1_x6 avg i(Vx2_x1_x6) from=2600n to=3000n
  meas tran vx2_x4 avg i(Vx2_x4) from=2600n to=3000n
  meas tran vx2_x11 avg i(Vx2_x11) from=2600n to=3000n
  meas tran vx2_x12 avg i(Vx2_x12) from=2600n to=3000n
  meas tran vx2_x20 avg i(Vx2_x20) from=2600n to=3000n
  meas tran vx3 avg i(Vx3) from=2600n to=3000n
  meas tran vx4 avg i(Vx4) from=2600n to=3000n
  meas tran vtie avg i(Vtie) from=2600n to=3000n
  meas tran vb avg i(Vb) from=2600n to=3000n
  meas tran vctrl_a avg v(x2_net1) from=2600n to=3000n
  meas tran vctrl_b avg v(x2_net1) from=2600n to=3000n
  meas tran vctrl_pp pp v(x2_net1) from=2600n to=3000n
  meas tran e_a when v(clkout_p)=0.9 rise=1 td=2600n
  meas tran e_b when v(clkout_p)=0.9 rise=201 td=2600n
  let f_mhz = 200/(e_b-e_a)/1e6
  print f_mhz
* charge-pump activity: CDR net2 = up, net3 = down (for comparison with ../cml)
  meas tran up_duty avg v(x2_net2) from=2600n to=3000n
  meas tran dn_duty avg v(x2_net3) from=2600n to=3000n
* startup: the precharge cell's current while it is seeding vctrl
  meas tran precharge_start avg i(Vx2_x20) from=2600n to=3000n
  let rclkp = v(rclk_p)
  let coutp = v(eq_p)
  let coutm = v(eq_m)
  set filetype=ascii
  write tt_typ_27C_1p98V_chain.raw rclkp coutp coutm
  wrdata tt_typ_27C_1p98V.dat v(x2_net1) v(x2_x2.cap_plus) v(x2_net2) v(x2_net3) v(rclk_p)
.endc
.end
