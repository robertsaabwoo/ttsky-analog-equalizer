* U3: frozen vs CML PD waveforms at -0.03 UI (is the frozen edge sample both-low?)
* bits 100011110010001011001110101001
.lib /home/ttuser/pdk/sky130A/libs.tech/ngspice/sky130.lib.spice tt
.include /home/ttuser/pdk/sky130A/libs.ref/sky130_fd_sc_hd/spice/sky130_fd_sc_hd.spice
.include /home/ttuser/ssh_analog/ttsky-analog-equalizer/xschem/tuning/cml/.netlists/frozen.inc
.include /home/ttuser/ssh_analog/ttsky-analog-equalizer/xschem/tuning/cml/.netlists/cml_cells.inc
.include /home/ttuser/ssh_analog/ttsky-analog-equalizer/xschem/tuning/vw/alex_probe.inc
.options method=gear reltol=0.001
Vdd vdd 0 1.8
Vb vbias 0 0.9
Vd vd 0 PWL(0.00000e+00 0.0750 1.66500e-09 0.0750 1.76500e-09 -0.0750 3.33000e-09 -0.0750 3.43000e-09 -0.0750 4.99500e-09 -0.0750 5.09500e-09 -0.0750 6.66000e-09 -0.0750 6.76000e-09 0.0750 8.32500e-09 0.0750 8.42500e-09 0.0750 9.99000e-09 0.0750 1.00900e-08 0.0750 1.16550e-08 0.0750 1.17550e-08 0.0750 1.33200e-08 0.0750 1.34200e-08 -0.0750 1.49850e-08 -0.0750 1.50850e-08 -0.0750 1.66500e-08 -0.0750 1.67500e-08 0.0750 1.83150e-08 0.0750 1.84150e-08 -0.0750 1.99800e-08 -0.0750 2.00800e-08 -0.0750 2.16450e-08 -0.0750 2.17450e-08 -0.0750 2.33100e-08 -0.0750 2.34100e-08 0.0750 2.49750e-08 0.0750 2.50750e-08 -0.0750 2.66400e-08 -0.0750 2.67400e-08 0.0750 2.83050e-08 0.0750 2.84050e-08 0.0750 2.99700e-08 0.0750 3.00700e-08 -0.0750 3.16350e-08 -0.0750 3.17350e-08 -0.0750 3.33000e-08 -0.0750 3.34000e-08 0.0750 3.49650e-08 0.0750 3.50650e-08 0.0750 3.66300e-08 0.0750 3.67300e-08 0.0750 3.82950e-08 0.0750 3.83950e-08 -0.0750 3.99600e-08 -0.0750 4.00600e-08 0.0750 4.16250e-08 0.0750 4.17250e-08 -0.0750 4.32900e-08 -0.0750 4.33900e-08 0.0750 4.49550e-08 0.0750 4.50550e-08 -0.0750 4.66200e-08 -0.0750 4.67200e-08 -0.0750 4.82850e-08 -0.0750 4.83850e-08 0.0750)
Ep dp 0 vol='1.3 + v(vd)'
Em dm 0 vol='1.3 - v(vd)'
Vck0 ck0 0 PULSE(0 1.8 7.4255e-10 8e-11 8e-11 7.5250e-10 1.665e-09)
xinv0 vdd 0 ck0 ckb0 single_inverter
xpd0 vdd 0 dn0 up0 ck0 dp ckb0 dm vbias bp0 bm0 q5p q5m q2p q2m alex_probe
xbg0 0 0 vdd vdd bn0 vdd 0 bpp0 tiny_pll_bias_gen
xcp0 vdd vdd 0 0 vc0 up0 dn0 bn0 bpp0 tiny_pll_charge_pump
Vvc0 vc0 0 0.79
Vck1 ck1 0 PULSE(1.03 1.43 6.8255e-10 2e-10 2e-10 6.3250e-10 1.665e-09)
Vckb1 ckb1 0 PULSE(1.43 1.03 6.8255e-10 200e-12 200e-12 6.3250e-10 1.665e-09)
xpd1 vdd 0 dn1 up1 ck1 ckb1 dp dm vbias cml_pd
xbg1 0 0 vdd vdd bn1 vdd 0 bpp1 tiny_pll_bias_gen
xcp1 vdd vdd 0 0 vc1 up1 dn1 bn1 bpp1 tiny_pll_charge_pump
Vvc1 vc1 0 0.79
.control
  save v(up0) v(dn0) v(bp0) v(bm0) v(q5p) v(q5m) v(q2p) v(q2m) i(Vvc0) v(up1) v(dn1) i(Vvc1) v(ck0) v(ckb0)
  tran 5p 4.9950e-08
  let i0 = -i(Vvc0)
  let i1 = -i(Vvc1)
  set filetype=ascii
  write U3_probe.raw up0 dn0 bp0 bm0 q5p q5m q2p q2m i0 up1 dn1 i1 ck0 ckb0
.endc
.end
