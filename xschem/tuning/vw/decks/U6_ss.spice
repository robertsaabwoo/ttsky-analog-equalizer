* U6: frozen PD at ss/27C -- why up/down stick high (U4). vbias and data CM swept.
* x1 = edge flop (x1.x1 master, x1.x2 slave latch); x5 = data flop. net1/net2 = latch core nodes.
* bits 100011110010001011001110101001
* corner: mos=ss rc=typ temp=27C
.param mc_mm_switch=0
.param mc_pr_switch=0
.include "/home/ttuser/pdk/sky130A/libs.tech/ngspice/corners/ss.spice"
.include "/home/ttuser/pdk/sky130A/libs.tech/ngspice/r+c/res_typical__cap_typical.spice"
.include "/home/ttuser/pdk/sky130A/libs.tech/ngspice/r+c/res_typical__cap_typical__lin.spice"
.include "/home/ttuser/pdk/sky130A/libs.tech/ngspice/corners/ss/specialized_cells.spice"
.temp 27

.include /home/ttuser/pdk/sky130A/libs.ref/sky130_fd_sc_hd/spice/sky130_fd_sc_hd.spice
.include /home/ttuser/ssh_analog/ttsky-analog-equalizer/xschem/tuning/cml/.netlists/frozen.inc
.include /home/ttuser/ssh_analog/ttsky-analog-equalizer/xschem/tuning/vw/alex_probe.inc
.options method=gear reltol=0.001
Vdd vdd 0 1.8
Vb vbias 0 0.9
Vcm vcm 0 1.3
Vd vd 0 PWL(0.00000e+00 0.0750 1.66500e-09 0.0750 1.76500e-09 -0.0750 3.33000e-09 -0.0750 3.43000e-09 -0.0750 4.99500e-09 -0.0750 5.09500e-09 -0.0750 6.66000e-09 -0.0750 6.76000e-09 0.0750 8.32500e-09 0.0750 8.42500e-09 0.0750 9.99000e-09 0.0750 1.00900e-08 0.0750 1.16550e-08 0.0750 1.17550e-08 0.0750 1.33200e-08 0.0750 1.34200e-08 -0.0750 1.49850e-08 -0.0750 1.50850e-08 -0.0750 1.66500e-08 -0.0750 1.67500e-08 0.0750 1.83150e-08 0.0750 1.84150e-08 -0.0750 1.99800e-08 -0.0750 2.00800e-08 -0.0750 2.16450e-08 -0.0750 2.17450e-08 -0.0750 2.33100e-08 -0.0750 2.34100e-08 0.0750 2.49750e-08 0.0750 2.50750e-08 -0.0750 2.66400e-08 -0.0750 2.67400e-08 0.0750 2.83050e-08 0.0750 2.84050e-08 0.0750 2.99700e-08 0.0750 3.00700e-08 -0.0750 3.16350e-08 -0.0750 3.17350e-08 -0.0750 3.33000e-08 -0.0750 3.34000e-08 0.0750 3.49650e-08 0.0750 3.50650e-08 0.0750 3.66300e-08 0.0750 3.67300e-08 0.0750 3.82950e-08 0.0750 3.83950e-08 -0.0750 3.99600e-08 -0.0750 4.00600e-08 0.0750 4.16250e-08 0.0750 4.17250e-08 -0.0750 4.32900e-08 -0.0750 4.33900e-08 0.0750 4.49550e-08 0.0750 4.50550e-08 -0.0750 4.66200e-08 -0.0750 4.67200e-08 -0.0750 4.82850e-08 -0.0750 4.83850e-08 0.0750)
Ep dp 0 vol='v(vcm) + v(vd)'
Em dm 0 vol='v(vcm) - v(vd)'
Vck0 ck0 0 PULSE(0 1.8 7.4255e-10 8e-11 8e-11 7.5250e-10 1.665e-09)
xinv0 vdd 0 ck0 ckb0 single_inverter
xpd0 vdd 0 dn0 up0 ck0 dp ckb0 dm vbias bp0 bm0 q5p q5m q2p q2m alex_probe
.control
  save v(up0) v(dn0) v(bp0) v(bm0) v(xpd0.x1.x1.net1) v(xpd0.x1.x1.net2) v(xpd0.x1.x2.net1) v(xpd0.x1.x2.net2) v(xpd0.x5.x1.net1) v(xpd0.x5.x1.net2)
  alter Vb dc=0.9
  alter Vcm dc=1.3
  tran 5p 4.9950e-08
  let em1 = v(xpd0.x1.x1.net1)
  let em2 = v(xpd0.x1.x1.net2)
  let es1 = v(xpd0.x1.x2.net1)
  let es2 = v(xpd0.x1.x2.net2)
  let dm1 = v(xpd0.x5.x1.net1)
  let dm2 = v(xpd0.x5.x1.net2)
  set filetype=ascii
  write U6_vb0p90_cm1p30.raw up0 dn0 bp0 bm0 em1 em2 es1 es2 dm1 dm2
  reset
  alter Vb dc=1.0
  alter Vcm dc=1.3
  tran 5p 4.9950e-08
  let em1 = v(xpd0.x1.x1.net1)
  let em2 = v(xpd0.x1.x1.net2)
  let es1 = v(xpd0.x1.x2.net1)
  let es2 = v(xpd0.x1.x2.net2)
  let dm1 = v(xpd0.x5.x1.net1)
  let dm2 = v(xpd0.x5.x1.net2)
  set filetype=ascii
  write U6_vb1p00_cm1p30.raw up0 dn0 bp0 bm0 em1 em2 es1 es2 dm1 dm2
  reset
  alter Vb dc=1.1
  alter Vcm dc=1.3
  tran 5p 4.9950e-08
  let em1 = v(xpd0.x1.x1.net1)
  let em2 = v(xpd0.x1.x1.net2)
  let es1 = v(xpd0.x1.x2.net1)
  let es2 = v(xpd0.x1.x2.net2)
  let dm1 = v(xpd0.x5.x1.net1)
  let dm2 = v(xpd0.x5.x1.net2)
  set filetype=ascii
  write U6_vb1p10_cm1p30.raw up0 dn0 bp0 bm0 em1 em2 es1 es2 dm1 dm2
  reset
  alter Vb dc=0.9
  alter Vcm dc=1.15
  tran 5p 4.9950e-08
  let em1 = v(xpd0.x1.x1.net1)
  let em2 = v(xpd0.x1.x1.net2)
  let es1 = v(xpd0.x1.x2.net1)
  let es2 = v(xpd0.x1.x2.net2)
  let dm1 = v(xpd0.x5.x1.net1)
  let dm2 = v(xpd0.x5.x1.net2)
  set filetype=ascii
  write U6_vb0p90_cm1p15.raw up0 dn0 bp0 bm0 em1 em2 es1 es2 dm1 dm2
  reset
.endc
.end
