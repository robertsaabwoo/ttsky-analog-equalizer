* Input common-mode sensitivity at the FINAL sizing, on the real TT pin channel.
* C7 found a cliff at 0.9 V, but that was the old sizing (Win 10 / Ldeg 1.5) and
* the old 1 pF channel.  Win 20 / Ldeg 5.0 has a different bias point entirely --
* far more degeneration means a different source-node voltage and a different
* tail Vds -- so the cliff has to be re-located before any bias network is drawn.
.lib /home/ttuser/pdk/sky130A/libs.tech/ngspice/sky130.lib.spice tt
.include ctle_p2.inc

.param vcm=0.9
.param cload=50f

VDD  VDD 0 1.8
VSS  VSS 0 0
Vb   vbias 0 0.9

Vsp  srcp 0 dc 'vcm' ac 0.5 0
Vsm  srcm 0 dc 'vcm' ac 0.5 180
Rp srcp inp 500
Rm srcm inm 500
Cp inp 0 5p
Cm inm 0 5p

x1 outp outm inp inm VDD VSS vbias ctle_p2
Clp outp 0 'cload'
Clm outm 0 'cload'

.options method=gear reltol=1e-4 abstol=1e-13 vntol=1e-7

.control
  alterparam Win   = 20
  alterparam Lload = 20
  alterparam Ldeg  = 5.0
  alterparam Wcap  = 18
  foreach cm 0.70 0.80 0.90 1.00 1.05 1.10 1.20 1.30
    alterparam vcm = $cm
    reset
    ac dec 60 1e5 3e10
    let gdb  = db(v(outp)-v(outm))
    let gind = db(v(inp)-v(inm))
    wrdata tmp.dat gdb gind
    shell echo ""
    shell echo "#PT vcm $cm"
    shell cat tmp.dat
  end
  shell rm -f tmp.dat
.endc
.end
