* Tuned CTLE across temperature and supply, at one MOS corner.
* The corner is selected by the .lib line, which run_corners.sh rewrites.
.lib /home/ttuser/pdk/sky130A/libs.tech/ngspice/sky130.lib.spice tt
.include ctle_p2.inc

.param vcm=0.9
.param vb=0.9
.param cload=50f
.param rch=500 cch=1p

VDD  VDD 0 1.8
VSS  VSS 0 0
Vb   vbias 0 'vb'

Vsp  srcp 0 dc 'vcm' ac 0.5 0
Vsm  srcm 0 dc 'vcm' ac 0.5 180
Rchp srcp inp 'rch'
Rchm srcm inm 'rch'
Cchp inp 0 'cch'
Cchm inm 0 'cch'

x1 outp outm inp inm VDD VSS vbias ctle_p2
Clp outp 0 'cload'
Clm outm 0 'cload'

.options method=gear reltol=1e-4 abstol=1e-13 vntol=1e-7

.control
  alterparam Lload = 20
  alterparam Ldeg  = 1.5
  alterparam Wcap  = 18
  reset
  foreach tmp -40 27 125
    foreach vdd 1.62 1.8 1.98
      set temp = $tmp
      alter VDD = $vdd
      op
      let voutcm = v(outp)
      let id1 = @m.x1.xm1.msky130_fd_pr__nfet_01v8[id]
      ac dec 60 1e5 3e10
      let gdb  = db(v(outp)-v(outm))
      let gind = db(v(inp)-v(inm))
      wrdata tmp.dat gdb gind
      shell echo "#PT temp $tmp vdd $vdd"
      shell cat tmp.dat
    end
  end
  shell rm -f tmp.dat
.endc
.end
