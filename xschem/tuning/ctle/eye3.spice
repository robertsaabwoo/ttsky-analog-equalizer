* CTLE eye vs channel loss vs BOOST — PRBS7 at 600.6 Mb/s.
* Same three-channel front end as eye2.spice, but here only the retuned topology
* is instantiated and the sizing is stepped through a low/medium/high boost
* ladder, one transient each.  Answers "which degeneration should we build if the
* channel turns out to be X" directly in eye height rather than in dB of ripple.
.lib /home/ttuser/pdk/sky130A/libs.tech/ngspice/sky130.lib.spice tt
.include ctle_p2.inc
.include prbs.inc

.param vcm=0.9
.param vb=0.9
.param cload=50f
.param rch=500
.param amp=0.2

VDD  VDD 0 1.8
VSS  VSS 0 0
Vb   vbias 0 'vb'

Esp  srcp 0 vol='vcm + amp*0.5*(v(dsrc)-0.5)'
Esm  srcm 0 vol='vcm - amp*0.5*(v(dsrc)-0.5)'

* --- channel A: 1 pF (f_p = 318 MHz) ---
Rap srcp inap 'rch'
Ram srcm inam 'rch'
Cap inap 0 1p
Cam inam 0 1p
xta taoutp taoutm inap inam VDD VSS vbias ctle_p2
Ctap taoutp 0 'cload'
Ctam taoutm 0 'cload'

* --- channel B: 2 pF (f_p = 159 MHz) ---
Rbp srcp inbp 'rch'
Rbm srcm inbm 'rch'
Cbp inbp 0 2p
Cbm inbm 0 2p
xtb tboutp tboutm inbp inbm VDD VSS vbias ctle_p2
Ctbp tboutp 0 'cload'
Ctbm tboutm 0 'cload'

* --- channel C: 4 pF (f_p = 80 MHz) ---
Rcp srcp incp 'rch'
Rcm srcm incm 'rch'
Ccp incp 0 4p
Ccm incm 0 4p
xtc tcoutp tcoutm incp incm VDD VSS vbias ctle_p2
Ctcp tcoutp 0 'cload'
Ctcm tcoutm 0 'cload'

.options method=gear reltol=1e-4 abstol=1e-13 vntol=1e-7

.control
  foreach ldg 1.5 3.0 5.0
    foreach wc 18 21 24
      alterparam Lload = 20
      alterparam Ldeg  = $ldg
      alterparam Wcap  = $wc
      reset
      tran 10p 211.5n 0 20p
      linearize
      let ina = v(inap)-v(inam)
      let inb = v(inbp)-v(inbm)
      let inc = v(incp)-v(incm)
      let ta  = v(taoutp)-v(taoutm)
      let tb  = v(tboutp)-v(tboutm)
      let tc  = v(tcoutp)-v(tcoutm)
      wrdata tmp.dat ina inb inc ta tb tc
      shell echo "#EYE Lload 20 Ldeg $ldg Wcap $wc"
      shell cat tmp.dat
    end
  end
  shell rm -f tmp.dat
.endc
.end
