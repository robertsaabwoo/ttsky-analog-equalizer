* Does the retuned SCHEMATIC reproduce the ladder deck's numbers?
* Subckt comes straight out of CTLE_tune.sch via subckt_src.sch, so this checks
* the schematic edit, not a hand-copy.  Compare against ac_tt_tt.log tt/27/1.8:
*   ctle_dc +6.19 dB, boost +7.14 dB, ctle @Nyq +13.32 dB, combined @Nyq -0.43 dB
.lib /home/ttuser/pdk/sky130A/libs.tech/ngspice/sky130.lib.spice tt
.include ctle_tune_sch.inc
VDD VDD 0 1.8
VSS VSS 0 0
Vb  vbias 0 0.9
Vsp srcp 0 dc 0.9 ac 0.5 0
Vsm srcm 0 dc 0.9 ac 0.5 180
Rp srcp inp 500
Rm srcm inm 500
Cp inp 0 5p
Cm inm 0 5p
x1 outp outm inp inm VDD VSS vbias CTLE_tune
Clp outp 0 50f
Clm outm 0 50f
.options method=gear reltol=1e-4 abstol=1e-13 vntol=1e-7
.control
  ac dec 60 1e5 3e10
  let gdb  = db(v(outp)-v(outm))
  let gind = db(v(inp)-v(inm))
  wrdata tmp.dat gdb gind
  shell echo "#PT schematic tt 27C 1.8V"
  shell cat tmp.dat
  shell rm -f tmp.dat
.endc
.end
