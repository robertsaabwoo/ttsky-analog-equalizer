* CTLE design-space sweep 1 — load resistor (Lload) x degeneration cap (Wcap)
* Channel model = the R=500 / C=1p single pole from CTLE_testbench.sch (f_p = 318 MHz).
* vsrc -> [channel] -> inp/inm -> [CTLE] -> outp/outm -> 50 fF (CDR PD input)
.lib /home/ttuser/pdk/sky130A/libs.tech/ngspice/sky130.lib.spice tt
.include ctle_p.inc

.param vcm=0.9
.param vb=0.9
.param cload=50f
.param rch=500 cch=1p

VDD  VDD 0 1.8
VSS  VSS 0 0
Vb   vbias 0 'vb'

Vsp  srcp 0 dc 'vcm' ac 0.5 0
Vsm  srcm 0 dc 'vcm' ac 0.5 180
Rchp srcp inp 'rch'
Rchm srcm inm 'rch'
Cchp inp 0 'cch'
Cchm inm 0 'cch'

x1 outp outm inp inm VDD VSS vbias ctle_p

Clp outp 0 'cload'
Clm outm 0 'cload'

.options method=gear reltol=1e-4 abstol=1e-13 vntol=1e-7

.control
  shell rm -f all1.dat
  foreach lld 16 12 8 6
    foreach wc 13 18 23 28
      alterparam Lload = $lld
      alterparam Wcap  = $wc
      reset
      op
      let voutcm = v(outp)
      let vsp = v(x1.sp)
      let vst = v(x1.st)
      ac dec 60 1e5 3e10
      let gdb  = db(v(outp)-v(outm))
      let gind = db(v(inp)-v(inm))
      wrdata tmp.dat gdb gind
      shell echo "#PT Lload $lld Wcap $wc" >> all1.dat
      shell cat tmp.dat >> all1.dat
      echo "OP Lload $lld Wcap $wc"
      print voutcm vsp vst
      destroy all
    end
  end
  shell rm -f tmp.dat
.endc
.end
