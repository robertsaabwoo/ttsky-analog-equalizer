* CTLE boost ladder against the REAL channel: the Tiny Tapeout analog pin path.
*
* tinytapeout.com/specs/analog/ guarantees the pad->user-project path is
*   series resistance < 500 ohm,  capacitance < 5 pF.
* Those are bounds, not typicals, and the split of the C either side of the R is
* not specified, so we lump all of it at the CTLE input -- the pessimistic case.
*   A = 500 ohm / 5.0 pF  -> pole  63.7 MHz   (spec worst case)
*   B = 350 ohm / 3.0 pF  -> pole 151.6 MHz   (mid)
*   C = 200 ohm / 1.5 pF  -> pole 530.5 MHz   (optimistic)
* At 600 Mb/s Nyquist is 300 MHz, so channel A alone loses 13.7 dB there.
*
* Sweep adds Win as a third axis: boost is capped by gm*Rdeg, so if the ladder
* needs more peaking than C10 could reach, more gm is the lever, not more cap.
.lib /home/ttuser/pdk/sky130A/libs.tech/ngspice/sky130.lib.spice tt
.include ctle_p2.inc

.param vcm=0.9
.param vb=0.9
.param cload=50f

VDD  VDD 0 1.8
VSS  VSS 0 0
Vb   vbias 0 'vb'

Vsp  srcp 0 dc 'vcm' ac 0.5 0
Vsm  srcm 0 dc 'vcm' ac 0.5 180

Rap srcp inap 500
Ram srcm inam 500
Cap inap 0 5p
Cam inam 0 5p
xa aoutp aoutm inap inam VDD VSS vbias ctle_p2
Cap2 aoutp 0 'cload'
Cam2 aoutm 0 'cload'

Rbp srcp inbp 350
Rbm srcm inbm 350
Cbp inbp 0 3p
Cbm inbm 0 3p
xb boutp boutm inbp inbm VDD VSS vbias ctle_p2
Cbp2 boutp 0 'cload'
Cbm2 boutm 0 'cload'

Rcp srcp incp 200
Rcm srcm incm 200
Ccp incp 0 1.5p
Ccm incm 0 1.5p
xc coutp coutm incp incm VDD VSS vbias ctle_p2
Ccp2 coutp 0 'cload'
Ccm2 coutm 0 'cload'

.options method=gear reltol=1e-4 abstol=1e-13 vntol=1e-7

.control
  foreach wi 10 20 40
    foreach ldg 1.5 3.0 5.0 8.0 12.0
      foreach wc 18 24 30
        alterparam Win   = $wi
        alterparam Lload = 20
        alterparam Ldeg  = $ldg
        alterparam Wcap  = $wc
        reset
        ac dec 40 1e5 1e10
        let ga = db(v(aoutp)-v(aoutm))
        let ia = db(v(inap)-v(inam))
        let gb = db(v(boutp)-v(boutm))
        let ib = db(v(inbp)-v(inbm))
        let gc = db(v(coutp)-v(coutm))
        let ic = db(v(incp)-v(incm))
        wrdata tmp.dat ga ia gb ib gc ic
        shell echo "#PT Win $wi Ldeg $ldg Wcap $wc"
        shell cat tmp.dat
      end
    end
  end
  shell rm -f tmp.dat
.endc
.end
