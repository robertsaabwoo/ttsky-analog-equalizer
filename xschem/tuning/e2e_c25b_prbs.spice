* =====================================================================
*  C25-B: PRBS7 at 3 us -- THE MERGE GATE
*
*  C24 ran PRBS7 to 2 us and the loop had NOT settled (vctrl 0.791 -> 0.828 V,
*  161 mV pp dither).  This runs it 50% longer to find out whether it settles
*  at all on real data.  If vctrl_w3 ~= vctrl_w4 it has; if it is still
*  climbing, the S16 loop-filter shrink needs re-deriving against PRBS.
*
*  Chain: data -> TT analog-pin LPF (500 ohm / 5 pF, both legs)
*         -> CTLE_tune -> CDR_tune -> rclk+ / rclk-
*
*  tran 20p 3000n, measured at 2800-2900 ns.  HEAVY (~40 min for the PRBS
*  decks).  RUN ONLY under safe_ngspice.sh.  save-limited, no bare `write`.
* =====================================================================
.lib /home/ttuser/pdk/sky130A/libs.tech/ngspice/sky130.lib.spice tt
.include /home/ttuser/pdk/sky130A/libs.ref/sky130_fd_sc_hd/spice/sky130_fd_sc_hd.spice
.include e2e_blocks.inc
.include e2e_prbs3u.inc
.options method=gear reltol=0.001 abstol=1e-12

.param vcm=0.9
.param amp=0.2
.param rpad=500 cpad=5p

VDD Vdd 0 1.8
VSS Vss 0 0
Vb  vbias 0 0.9

* --- PRBS7 data (1850 bits, runs up to 7 UI) from e2e_prbs3u.inc ---
Edinp dinp 0 vol='vcm + 0.5*amp*(v(dsrc)-0.5)'
Edinm dinm 0 vol='vcm - 0.5*amp*(v(dsrc)-0.5)'

* --- TinyTapeout pad LPF on BOTH legs ---
Rpadp dinp cinp 'rpad'
Cpadp cinp 0    'cpad'
Rpadm dinm cinm 'rpad'
Cpadm cinm 0    'cpad'

x_ctle coutp coutm cinp cinm Vdd Vss vbias CTLE_tune
x_cdr  Vdd Vss coutp coutm vbias rclkp rclkm CDR_tune

* --- POR cap discharged at t=0 so the precharge one-shot can fire (NOTES 19a) ---
.ic v(x_cdr.x20.nrc)=0
.op

.control
  save v(x_cdr.net1) v(rclkp) v(rclkm) v(coutp) v(coutm) v(cinp) v(cinm) v(x_cdr.x20.pre)
  tran 20p 3000n
  let vctrl  = v(x_cdr.net1)
  let ctle_d = v(coutp)-v(coutm)
  let cin_d  = v(cinp)-v(cinm)
  let rsum   = v(rclkp)+v(rclkm)

* --- settled?  four windows across the run make drift unmistakable ---
  meas tran vctrl_w1 AVG v(x_cdr.net1) FROM=1000n TO=1100n
  meas tran vctrl_w2 AVG v(x_cdr.net1) FROM=1800n TO=1900n
  meas tran vctrl_w3 AVG v(x_cdr.net1) FROM=2400n TO=2500n
  meas tran vctrl_w4 AVG v(x_cdr.net1) FROM=2800n TO=2900n
  meas tran vctrl_ripp PP v(x_cdr.net1) FROM=2800n TO=2900n
  meas tran t_release  WHEN v(x_cdr.x20.pre)=0.9 FALL=1

* --- both recovered clocks ---
  meas tran rclkp_swing PP  v(rclkp) FROM=2800n TO=2900n
  meas tran rclkm_swing PP  v(rclkm) FROM=2800n TO=2900n
  meas tran rclkp_avg   AVG v(rclkp) FROM=2800n TO=2900n
  meas tran rclkm_avg   AVG v(rclkm) FROM=2800n TO=2900n
  meas tran rsum_avg    AVG rsum     FROM=2800n TO=2900n
  meas tran rsum_pp     PP  rsum     FROM=2800n TO=2900n

* --- what the CTLE handed the CDR ---
  meas tran cin_swing  PP cin_d  FROM=2800n TO=2900n
  meas tran ctle_swing PP ctle_d FROM=2800n TO=2900n

* --- frequency LATE (2.80-2.90 us) and EARLY (1.00-1.10 us); drift = not locked
  meas tran p1680 WHEN v(rclkp)=0.9 RISE=1680
  meas tran p1740 WHEN v(rclkp)=0.9 RISE=1740
  meas tran m1680 WHEN v(rclkm)=0.9 RISE=1680
  meas tran m1740 WHEN v(rclkm)=0.9 RISE=1740
  meas tran p600  WHEN v(rclkp)=0.9 RISE=600
  meas tran p660  WHEN v(rclkp)=0.9 RISE=660
  let fp_late_MHz  = 60/(p1740-p1680)/1e6
  let fm_late_MHz  = 60/(m1740-m1680)/1e6
  let fp_early_MHz = 60/(p660-p600)/1e6
  print fp_late_MHz
  print fm_late_MHz
  print fp_early_MHz
.endc
.end
