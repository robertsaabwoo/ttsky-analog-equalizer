* =====================================================================
*  END-TO-END gate test:  small-signal diff data
*     -> TinyTapeout analog-pin LPF (500 ohm / 5 pF, both legs)
*     -> CTLE_tune  -> CDR_tune  -> recovered clock
*
*  Required before merging the CTLE to main (user, 2026-08-02).
*  This is the FIRST time the CTLE and the CDR are simulated as one loop
*  (the C12 chain check stopped at the CTLE output; it never fed the CDR).
*
*  Subckts (CDR hierarchy incl. the x20 precharge + CTLE_tune) are in
*  e2e_blocks.inc, harvested from a FRESH netlist of CDR_tune_tb.sch so
*  they reflect the validated design (variant-E clk, precharge, _tune PD).
*
*  Input is 200 mVpp differential at CM=0.9 V: small-signal so the CTLE
*  actually equalizes instead of limiting (NOTES_CTLE C8 — rail input is
*  8.5 dB compressed and EQ cannot show up).  CTLE feeds the CDR directly
*  (no limiter between), per the user's "straight into CDR" choice.
*
*  HEAVY: full CDR+CTLE transient, 20p x 1500n = 75000 pts, ~10-15 min.
*  RUN ONLY under safe_ngspice.sh.  `save`-limited, no bare `write`.
* =====================================================================
.lib /home/ttuser/pdk/sky130A/libs.tech/ngspice/sky130.lib.spice tt
.include /home/ttuser/pdk/sky130A/libs.ref/sky130_fd_sc_hd/spice/sky130_fd_sc_hd.spice
.include e2e_blocks.inc
.options method=gear reltol=0.001 abstol=1e-12

.param vcm=0.9          ; CTLE input common mode (CDR data CM; see C7)
.param amp=0.2          ; 200 mVpp differential at the source (linear, C8)
.param rpad=500 cpad=5p ; TT analog-pin spec worst case -> pole 63.7 MHz (C16)

VDD Vdd 0 1.8
VSS Vss 0 0
Vb  vbias 0 0.9

* --- differential 0101 data at the baud rate (UI 1.665 ns -> 600.6 Mb/s) ---
Vdraw draw 0 PULSE(0 1 0 10p 10p 1.665n 3.33n)
Edinp dinp 0 vol='vcm + 0.5*amp*(v(draw)-0.5)'
Edinm dinm 0 vol='vcm - 0.5*amp*(v(draw)-0.5)'

* --- TinyTapeout pad LPF on BOTH legs: series R (mux+pad) + shunt C (pad) ---
Rpadp dinp cinp 'rpad'
Cpadp cinp 0    'cpad'
Rpadm dinm cinm 'rpad'
Cpadm cinm 0    'cpad'

* --- CTLE_tune: (vout+ vout- vin+ vin- VDD VSS vbias) ---
x_ctle coutp coutm cinp cinm Vdd Vss vbias CTLE_tune

* --- CDR_tune: (Vdd Vss vin+ vin- vbias rclk+ rclk-) ; data = CTLE output ---
*     recovered clock brought out on '+'-free top nodes rclkp/rclkm.
x_cdr Vdd Vss coutp coutm vbias rclkp rclkm CDR_tune

* --- POR cap discharged at t=0 so the precharge one-shot can fire (NOTES 19a) ---
.ic v(x_cdr.x20.nrc)=0
.op

.control
* save-limited: keep only what the measures need (memory + no OOM)
  save v(x_cdr.net1) v(rclkp) v(rclkm) v(coutp) v(coutm) v(cinp) v(cinm) v(x_cdr.x20.pre)
  tran 20p 1500n
  let vctrl  = v(x_cdr.net1)
  let ctle_d = v(coutp)-v(coutm)
  let cin_d  = v(cinp)-v(cinm)
* --- did the loop lock? (vctrl settled, clock rail-to-rail, right frequency) ---
  meas tran vctrl_lock AVG v(x_cdr.net1) FROM=1300n TO=1400n
  meas tran vctrl_ripp PP  v(x_cdr.net1) FROM=1300n TO=1400n
  meas tran rclk_swing PP  v(rclkp)      FROM=1300n TO=1400n
  meas tran t_release  WHEN v(x_cdr.x20.pre)=0.9 FALL=1
* --- what the CTLE handed the CDR (channel-in vs CTLE-out swing) ---
  meas tran cin_swing  PP  cin_d         FROM=1300n TO=1400n
  meas tran ctle_swing PP  ctle_d        FROM=1300n TO=1400n
* --- recovered-clock frequency over 60 cycles in the locked window ---
  meas tran c600 WHEN v(rclkp)=0.9 RISE=600
  meas tran c660 WHEN v(rclkp)=0.9 RISE=660
  let f_MHz = 60/(c660-c600)/1e6
  print f_MHz
.endc
.end
