* reference.spice -- GENERATED by gen_cml_sch.py from the simulated .inc files; do not edit

.subckt cml_latch q qb d db VDD VSS ck ckb vbias
XMd qb d s1 VSS sky130_fd_pr__nfet_01v8 L=0.15 W=2 nf=1 ad={2*0.29} as={2*0.29} pd={2*(2+0.29)} ps={2*(2+0.29)} nrd=0 nrs=0 sa=0 sb=0 sd=0
XMdb q db s1 VSS sky130_fd_pr__nfet_01v8 L=0.15 W=2 nf=1 ad={2*0.29} as={2*0.29} pd={2*(2+0.29)} ps={2*(2+0.29)} nrd=0 nrs=0 sa=0 sb=0 sd=0
XMr1 q qb s2 VSS sky130_fd_pr__nfet_01v8 L=0.15 W=2 nf=1 ad={2*0.29} as={2*0.29} pd={2*(2+0.29)} ps={2*(2+0.29)} nrd=0 nrs=0 sa=0 sb=0 sd=0
XMr2 qb q s2 VSS sky130_fd_pr__nfet_01v8 L=0.15 W=2 nf=1 ad={2*0.29} as={2*0.29} pd={2*(2+0.29)} ps={2*(2+0.29)} nrd=0 nrs=0 sa=0 sb=0 sd=0
XMc s1 ck tail VSS sky130_fd_pr__nfet_01v8 L=0.15 W=2 nf=1 ad={2*0.29} as={2*0.29} pd={2*(2+0.29)} ps={2*(2+0.29)} nrd=0 nrs=0 sa=0 sb=0 sd=0
XMcb s2 ckb tail VSS sky130_fd_pr__nfet_01v8 L=0.15 W=2 nf=1 ad={2*0.29} as={2*0.29} pd={2*(2+0.29)} ps={2*(2+0.29)} nrd=0 nrs=0 sa=0 sb=0 sd=0
XMt tail vbias VSS VSS sky130_fd_pr__nfet_01v8 L=0.5 W=3 nf=1 ad={3*0.29} as={3*0.29} pd={2*(3+0.29)} ps={2*(3+0.29)} nrd=0 nrs=0 sa=0 sb=0 sd=0
XR1 q VDD VSS sky130_fd_pr__res_high_po_0p69 L=14
XR2 qb VDD VSS sky130_fd_pr__res_high_po_0p69 L=14
.ends

.subckt cml_dff Q Qb D Db VDD VSS ck ckb vbias
xm m mb D Db VDD VSS ckb ck vbias cml_latch
xs Q Qb m mb VDD VSS ck ckb vbias cml_latch
.ends

.subckt cml2cmos out inp inm VDD VSS vbias
XM1 x inp t VSS sky130_fd_pr__nfet_01v8 L=0.15 W=2 nf=1 ad={2*0.29} as={2*0.29} pd={2*(2+0.29)} ps={2*(2+0.29)} nrd=0 nrs=0 sa=0 sb=0 sd=0
XM2 y inm t VSS sky130_fd_pr__nfet_01v8 L=0.15 W=2 nf=1 ad={2*0.29} as={2*0.29} pd={2*(2+0.29)} ps={2*(2+0.29)} nrd=0 nrs=0 sa=0 sb=0 sd=0
XP1 x x VDD VDD sky130_fd_pr__pfet_01v8 L=0.15 W=1 nf=1 ad={1*0.29} as={1*0.29} pd={2*(1+0.29)} ps={2*(1+0.29)} nrd=0 nrs=0 sa=0 sb=0 sd=0
XP2 y x VDD VDD sky130_fd_pr__pfet_01v8 L=0.15 W=1 nf=1 ad={1*0.29} as={1*0.29} pd={2*(1+0.29)} ps={2*(1+0.29)} nrd=0 nrs=0 sa=0 sb=0 sd=0
XMt t vbias VSS VSS sky130_fd_pr__nfet_01v8 L=0.5 W=1 nf=1 ad={1*0.29} as={1*0.29} pd={2*(1+0.29)} ps={2*(1+0.29)} nrd=0 nrs=0 sa=0 sb=0 sd=0
XPi1 z y VDD VDD sky130_fd_pr__pfet_01v8 L=0.15 W=1 nf=1 ad={1*0.29} as={1*0.29} pd={2*(1+0.29)} ps={2*(1+0.29)} nrd=0 nrs=0 sa=0 sb=0 sd=0
XNi1 z y VSS VSS sky130_fd_pr__nfet_01v8 L=0.15 W=0.5 nf=1 ad={0.5*0.29} as={0.5*0.29} pd={2*(0.5+0.29)} ps={2*(0.5+0.29)} nrd=0 nrs=0 sa=0 sb=0 sd=0
XPi2 out z VDD VDD sky130_fd_pr__pfet_01v8 L=0.15 W=2 nf=1 ad={2*0.29} as={2*0.29} pd={2*(2+0.29)} ps={2*(2+0.29)} nrd=0 nrs=0 sa=0 sb=0 sd=0
XNi2 out z VSS VSS sky130_fd_pr__nfet_01v8 L=0.15 W=1 nf=1 ad={1*0.29} as={1*0.29} pd={2*(1+0.29)} ps={2*(1+0.29)} nrd=0 nrs=0 sa=0 sb=0 sd=0
.ends

.subckt cml2cmos_w2 out inp inm VDD VSS vbias
XM1 x inp t VSS sky130_fd_pr__nfet_01v8 L=0.15 W=2 nf=1 ad={2*0.29} as={2*0.29} pd={2*(2+0.29)} ps={2*(2+0.29)} nrd=0 nrs=0 sa=0 sb=0 sd=0
XM2 y inm t VSS sky130_fd_pr__nfet_01v8 L=0.15 W=2 nf=1 ad={2*0.29} as={2*0.29} pd={2*(2+0.29)} ps={2*(2+0.29)} nrd=0 nrs=0 sa=0 sb=0 sd=0
XP1 x x VDD VDD sky130_fd_pr__pfet_01v8 L=0.15 W=1 nf=1 ad={1*0.29} as={1*0.29} pd={2*(1+0.29)} ps={2*(1+0.29)} nrd=0 nrs=0 sa=0 sb=0 sd=0
XP2 y x VDD VDD sky130_fd_pr__pfet_01v8 L=0.15 W=1 nf=1 ad={1*0.29} as={1*0.29} pd={2*(1+0.29)} ps={2*(1+0.29)} nrd=0 nrs=0 sa=0 sb=0 sd=0
XMt t vbias VSS VSS sky130_fd_pr__nfet_01v8 L=0.5 W=2 nf=1 ad={2*0.29} as={2*0.29} pd={2*(2+0.29)} ps={2*(2+0.29)} nrd=0 nrs=0 sa=0 sb=0 sd=0
XPi1 z y VDD VDD sky130_fd_pr__pfet_01v8 L=0.15 W=1 nf=1 ad={1*0.29} as={1*0.29} pd={2*(1+0.29)} ps={2*(1+0.29)} nrd=0 nrs=0 sa=0 sb=0 sd=0
XNi1 z y VSS VSS sky130_fd_pr__nfet_01v8 L=0.15 W=0.5 nf=1 ad={0.5*0.29} as={0.5*0.29} pd={2*(0.5+0.29)} ps={2*(0.5+0.29)} nrd=0 nrs=0 sa=0 sb=0 sd=0
XPi2 out z VDD VDD sky130_fd_pr__pfet_01v8 L=0.15 W=2 nf=1 ad={2*0.29} as={2*0.29} pd={2*(2+0.29)} ps={2*(2+0.29)} nrd=0 nrs=0 sa=0 sb=0 sd=0
XNi2 out z VSS VSS sky130_fd_pr__nfet_01v8 L=0.15 W=1 nf=1 ad={1*0.29} as={1*0.29} pd={2*(1+0.29)} ps={2*(1+0.29)} nrd=0 nrs=0 sa=0 sb=0 sd=0
.ends

.subckt cx_xor A B X VDD VSS
x0 A B VSS VSS VDD VDD X sky130_fd_sc_hd__xor2_1
.ends

.subckt cml_pd_cx3w VDD VSS down up ck ckb d db vbias
x5 q5 q5b d db VDD VSS ck ckb vbias cml_dff
x1 q1 q1b d db VDD VSS ckb ck vbias cml_dff
x2 q2 q2b q5 q5b VDD VSS ck ckb vbias cml_dff
x3 b bb q1 q1b VDD VSS ck ckb vbias cml_dff
xc5 a5 q5 q5b VDD VSS vbias cml2cmos_w2
xc2 a2 q2 q2b VDD VSS vbias cml2cmos_w2
xcb bp b bb VDD VSS vbias cml2cmos_w2
x6 a5 bp down VDD VSS cx_xor
x7 a2 bp up VDD VSS cx_xor
.ends

.subckt cml_bias VDD VSS vbn
XRr vbn VDD VSS sky130_fd_pr__res_high_po_0p69 L=112
XD vbn vbn VSS VSS sky130_fd_pr__nfet_01v8 W=0.75 L=0.5
XCd VSS vbn VSS VSS sky130_fd_pr__nfet_01v8 W=5 L=5
.ends

.subckt cml_clkbuf VDD VSS vo- vo+ vin- vin+ vbn
XM2 vo-_temp vin- net1 VSS sky130_fd_pr__nfet_01v8 L=0.15 W=3 nf=1
XM3 net1 vbn VSS VSS sky130_fd_pr__nfet_01v8 L=0.5 W=0.96 nf=1
XM6 vo+_temp vin+ net1 VSS sky130_fd_pr__nfet_01v8 L=0.15 W=3 nf=1
XR3 vo+_temp VDD VSS sky130_fd_pr__res_high_po W=0.5 L=10 mult=1
XR4 vo-_temp VDD VSS sky130_fd_pr__res_high_po W=0.5 L=10 mult=1
XM1 vo- vo-_temp net2 VSS sky130_fd_pr__nfet_01v8 L=0.5 W=6 nf=1
XM4 net2 vbn VSS VSS sky130_fd_pr__nfet_01v8 L=0.5 W=8.9 nf=2
XM5 vo+ vo+_temp net2 VSS sky130_fd_pr__nfet_01v8 L=0.5 W=6 nf=1
XR1 vo+ VDD VSS sky130_fd_pr__res_high_po W=1 L=17.5 mult=1
XR2 vo- VDD VSS sky130_fd_pr__res_high_po W=1 L=17.5 mult=1
.ends

.subckt cp_bias VDD VSS bias_n bias_p
XR bias_n VDD VSS sky130_fd_pr__res_xhigh_po_0p35 L=163 mult=1
XND bias_n bias_n VSS VSS sky130_fd_pr__nfet_01v8 L=1 W=1
XNM bias_p bias_n VSS VSS sky130_fd_pr__nfet_01v8 L=1 W=1
XPD bias_p bias_p VDD VDD sky130_fd_pr__pfet_01v8 L=1 W=2
.ends

.subckt cml_loop_filter VGND VNB VPWR VPB vctl
XMC1 VGND cap_plus VGND VNB sky130_fd_pr__nfet_01v8 L=0.6 W=4 nf=1 ad='int((nf+1)/2) * W/nf * 0.29' as='int((nf+2)/2) * W/nf * 0.29' pd='2*int((nf+1)/2) * (W/nf + 0.29)' ps='2*int((nf+2)/2) * (W/nf + 0.29)' nrd='0.29 / W' nrs='0.29 / W' sa=0 sb=0 sd=0 mult=16 m=16
XR cap_plus vctl VNB sky130_fd_pr__res_xhigh_po_0p35 L=5.7 mult=1 m=1
XMC2 VGND vctl VGND VNB sky130_fd_pr__nfet_01v8 L=2 W=2.94 nf=1 ad='int((nf+1)/2) * W/nf * 0.29' as='int((nf+2)/2) * W/nf * 0.29' pd='2*int((nf+1)/2) * (W/nf + 0.29)' ps='2*int((nf+2)/2) * (W/nf + 0.29)' nrd='0.29 / W' nrs='0.29 / W' sa=0 sb=0 sd=0 mult=1 m=1
.ends

.subckt ring_core Vdd Vss vctrl t7 t8
x1 Vdd Vss t7 n1 t8 n2 vctrl ring_inverter
x2 Vdd Vss n1 n4 n2 n3 vctrl ring_inverter
x3 Vdd Vss n4 n5 n3 n6 vctrl ring_inverter
x5 Vdd Vss n5 n9 n6 n10 vctrl ring_inverter
x4 Vdd Vss n9 t7 n10 t8 vctrl ring_inverter
.ends

.subckt CDR_cml Vdd Vss vin+ vin- vbias rclk+ rclk-
x6 Vdd Vdd Vss Vss net1 net2 net3 bias_n bias_p tiny_pll_charge_pump
x8 Vdd Vss bias_n bias_p cp_bias
x2 Vss Vss Vdd Vdd net1 cml_loop_filter
x1 Vdd Vss net1 t7 t8 ring_core
x9 Vdd Vss ck ckb t7 t8 vbn cml_clkbuf
xref Vdd Vss vbn cml_bias
x3 Vdd Vss net3 net2 ck ckb vin+ vin- vbn cml_pd_cx3w
x11 rclk+ ck ckb Vdd Vss vbn cml2cmos
x12 rclk- ckb ck Vdd Vss vbn cml2cmos
x20 Vdd Vss net1 vctrl_precharge
.ends

.subckt ctle_cdr_rx_cml vinp vinm vbias clkout_p clkout_n VDPWR VGND
x1 eq_p eq_m vinp vinm VDPWR VGND vbias CTLE
x2 VDPWR VGND eq_p eq_m vbias rclk_p rclk_m CDR_cml
x3 VDPWR VGND rclk_p clkout_p inverter_chain
x4 VDPWR VGND rclk_m clkout_n inverter_chain
.ends
